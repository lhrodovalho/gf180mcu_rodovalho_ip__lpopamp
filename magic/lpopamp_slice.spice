* NGSPICE file created from lpopamp_slice.ext - technology: gf180mcuC

.subckt lpopamp_slice inm inp o avdd avss en ib vsub zpm znm
X0 a_2244_1512# znp ynp avss nfet_06v0 ad=1.98p pd=7.2u as=1.98p ps=7.2u w=6.6u l=0.6u
X1 a_2460_2052# bpb znp avdd pfet_06v0 ad=1.98p pd=7.2u as=1.98p ps=7.2u w=6.6u l=0.6u
X2 a_n972_1512# bna a_n996_1512# avss nfet_06v0 ad=1.98p pd=7.2u as=1.98p ps=7.2u w=6.6u l=0.6u
X3 o znm a_4740_1512# avss nfet_06v0 ad=1.98p pd=7.2u as=1.98p ps=7.2u w=6.6u l=0.6u
X4 a_2052_2052# bpa avdd avdd pfet_06v0 ad=1.98p pd=7.2u as=1.98p ps=7.2u w=6.6u l=0.6u
X5 a_2076_2220# bpa a_2052_2220# avdd pfet_06v0 ad=1.98p pd=7.2u as=1.98p ps=7.2u w=6.6u l=0.6u
X6 bpb bpb bpa_ avdd pfet_06v0 ad=1.98p pd=7.2u as=1.98p ps=7.2u w=6.6u l=0.6u
X7 a_2964_2052# zpp ypp avdd pfet_06v0 ad=1.98p pd=7.2u as=1.98p ps=7.2u w=6.6u l=0.6u
X8 avdd a_120_2047# a_120_2047# avdd pfet_06v0 ad=1.98p pd=7.2u as=1.98p ps=7.2u w=6.6u l=0.6u
X9 a_2988_2220# zpp a_2964_2220# avdd pfet_06v0 ad=1.98p pd=7.2u as=1.98p ps=7.2u w=6.6u l=0.6u
X10 avdd zpm o avdd pfet_06v0 ad=1.98p pd=7.2u as=1.98p ps=7.2u w=6.6u l=0.6u
X11 o zpm avdd avdd pfet_06v0 ad=1.98p pd=7.2u as=1.98p ps=7.2u w=6.6u l=0.6u
X12 znp bpb a_2460_2052# avdd pfet_06v0 ad=1.98p pd=7.2u as=1.98p ps=7.2u w=6.6u l=0.6u
X13 xn inp a_1716_1344# avss nfet_06v0 ad=1.98p pd=7.2u as=1.98p ps=7.2u w=6.6u l=0.6u
X14 a_2292_1512# znp znp avss nfet_06v0 ad=1.98p pd=7.2u as=1.98p ps=7.2u w=6.6u l=0.6u
X15 a_3348_1344# bna a_3324_1344# avss nfet_06v0 ad=1.98p pd=7.2u as=1.98p ps=7.2u w=6.6u l=0.6u
X16 a_n1308_1344# en avss avss nfet_06v0 ad=1.98p pd=7.2u as=3.96p ps=14.4u w=6.6u l=0.6u
X17 ypp zpp zpp avdd pfet_06v0 ad=1.98p pd=7.2u as=1.98p ps=7.2u w=6.6u l=0.6u
X18 a_3828_1512# a_n840_1339# znm avss nfet_06v0 ad=1.98p pd=7.2u as=1.98p ps=7.2u w=6.6u l=0.6u
X19 xp1 inm ynp avdd pfet_06v0 ad=1.98p pd=7.2u as=1.98p ps=7.2u w=6.6u l=0.6u
X20 ynp inm xp1 avdd pfet_06v0 ad=1.98p pd=7.2u as=1.98p ps=7.2u w=6.6u l=0.6u
X21 zpm bpb znm avdd pfet_06v0 ad=1.98p pd=7.2u as=1.98p ps=7.2u w=6.6u l=0.6u
X22 ypp inm a_1764_1344# avss nfet_06v0 ad=1.98p pd=7.2u as=1.98p ps=7.2u w=6.6u l=0.6u
X23 znm bpb zpm avdd pfet_06v0 ad=1.98p pd=7.2u as=1.98p ps=7.2u w=6.6u l=0.6u
X24 a_3396_1344# znp avss avss nfet_06v0 ad=1.98p pd=7.2u as=1.98p ps=7.2u w=6.6u l=0.6u
X25 a_1332_1344# bna a_1308_1344# avss nfet_06v0 ad=1.98p pd=7.2u as=1.98p ps=7.2u w=6.6u l=0.6u
X26 a_1356_1512# bna a_1332_1512# avss nfet_06v0 ad=1.98p pd=7.2u as=1.98p ps=7.2u w=6.6u l=0.6u
X27 zpm a_n840_1339# a_3828_1344# avss nfet_06v0 ad=1.98p pd=7.2u as=1.98p ps=7.2u w=6.6u l=0.6u
X28 a_n840_1339# a_n840_1339# a_n252_1344# avss nfet_06v0 ad=1.98p pd=7.2u as=1.98p ps=7.2u w=6.6u l=0.6u
X29 a_1812_1512# inm ypp avss nfet_06v0 ad=1.98p pd=7.2u as=1.98p ps=7.2u w=6.6u l=0.6u
X30 a_4020_1344# a_n840_1339# znm avss nfet_06v0 ad=1.98p pd=7.2u as=1.98p ps=7.2u w=6.6u l=0.6u
X31 a_828_1344# znp a_804_1344# avss nfet_06v0 ad=1.98p pd=7.2u as=1.98p ps=7.2u w=6.6u l=0.6u
X32 a_3876_1512# a_n840_1339# zpm avss nfet_06v0 ad=1.98p pd=7.2u as=1.98p ps=7.2u w=6.6u l=0.6u
X33 xp1 inm ynp avdd pfet_06v0 ad=1.98p pd=7.2u as=1.98p ps=7.2u w=6.6u l=0.6u
X34 a_1188_2220# bpa xp1 avdd pfet_06v0 ad=1.98p pd=7.2u as=1.98p ps=7.2u w=6.6u l=0.6u
X35 bpa en a_n1212_2052# avdd pfet_06v0 ad=1.98p pd=7.2u as=1.98p ps=7.2u w=6.6u l=0.6u
X36 zpm bpb znm avdd pfet_06v0 ad=1.98p pd=7.2u as=1.98p ps=7.2u w=6.6u l=0.6u
X37 a_n840_1339# a_n840_1339# a_n732_1512# avss nfet_06v0 ad=1.98p pd=7.2u as=1.98p ps=7.2u w=6.6u l=0.6u
X38 znm bpb zpm avdd pfet_06v0 ad=1.98p pd=7.2u as=1.98p ps=7.2u w=6.6u l=0.6u
X39 ynp inm xp0 avdd pfet_06v0 ad=1.98p pd=7.2u as=1.98p ps=7.2u w=6.6u l=0.6u
X40 avdd zpp a_1620_2220# avdd pfet_06v0 ad=1.98p pd=7.2u as=1.98p ps=7.2u w=6.6u l=0.6u
X41 zpp zpp ypp avdd pfet_06v0 ad=1.98p pd=7.2u as=1.98p ps=7.2u w=6.6u l=0.6u
X42 a_n516_2052# bpa a_n540_2052# avdd pfet_06v0 ad=1.98p pd=7.2u as=1.98p ps=7.2u w=6.6u l=0.6u
X43 a_1404_1512# bna a_1380_1512# avss nfet_06v0 ad=1.98p pd=7.2u as=1.98p ps=7.2u w=6.6u l=0.6u
X44 a_120_2047# a_120_2047# a_204_2220# avdd pfet_06v0 ad=1.98p pd=7.2u as=1.98p ps=7.2u w=6.6u l=0.6u
X45 znp znp a_2436_1344# avss nfet_06v0 ad=1.98p pd=7.2u as=1.98p ps=7.2u w=6.6u l=0.6u
X46 bna_ a_n840_1339# a_n300_1344# avss nfet_06v0 ad=1.98p pd=7.2u as=1.98p ps=7.2u w=6.6u l=0.6u
X47 a_n1212_2220# en avdd avdd pfet_06v0 ad=1.98p pd=7.2u as=1.98p ps=7.2u w=6.6u l=0.6u
X48 a_4068_1344# a_n840_1339# zpm avss nfet_06v0 ad=1.98p pd=7.2u as=1.98p ps=7.2u w=6.6u l=0.6u
X49 avss znp a_852_1344# avss nfet_06v0 ad=1.98p pd=7.2u as=1.98p ps=7.2u w=6.6u l=0.6u
X50 a_900_1512# znp avss avss nfet_06v0 ad=1.98p pd=7.2u as=1.98p ps=7.2u w=6.6u l=0.6u
X51 a_444_1512# bna a_420_1512# avss nfet_06v0 ad=1.98p pd=7.2u as=1.98p ps=7.2u w=6.6u l=0.6u
X52 avss bna a_2004_1512# avss nfet_06v0 ad=1.98p pd=7.2u as=1.98p ps=7.2u w=6.6u l=0.6u
X53 a_2916_1344# a_n840_1339# a_2892_1344# avss nfet_06v0 ad=1.98p pd=7.2u as=1.98p ps=7.2u w=6.6u l=0.6u
X54 a_n732_1344# a_n840_1339# bna_ avss nfet_06v0 ad=1.98p pd=7.2u as=1.98p ps=7.2u w=6.6u l=0.6u
X55 bna_ a_n840_1339# a_n780_1512# avss nfet_06v0 ad=1.98p pd=7.2u as=1.98p ps=7.2u w=6.6u l=0.6u
X56 avss znm a_4500_1344# avss nfet_06v0 ad=1.98p pd=7.2u as=1.98p ps=7.2u w=6.6u l=0.6u
X57 zpp a_n840_1339# a_2916_1512# avss nfet_06v0 ad=1.98p pd=7.2u as=1.98p ps=7.2u w=6.6u l=0.6u
X58 ynm inp xp0 avdd pfet_06v0 ad=1.98p pd=7.2u as=1.98p ps=7.2u w=6.6u l=0.6u
X59 a_4548_1512# znm avss avss nfet_06v0 ad=1.98p pd=7.2u as=1.98p ps=7.2u w=6.6u l=0.6u
X60 a_1692_2220# zpp a_1668_2220# avdd pfet_06v0 ad=1.98p pd=7.2u as=1.98p ps=7.2u w=6.6u l=0.6u
X61 a_n300_1512# a_n840_1339# a_n840_1339# avss nfet_06v0 ad=1.98p pd=7.2u as=1.98p ps=7.2u w=6.6u l=0.6u
X62 bpa_ bpb bpb avdd pfet_06v0 ad=1.98p pd=7.2u as=1.98p ps=7.2u w=6.6u l=0.6u
X63 a_252_2052# a_120_2047# a_120_2047# avdd pfet_06v0 ad=1.98p pd=7.2u as=1.98p ps=7.2u w=6.6u l=0.6u
X64 a_2748_2052# zpp a_2724_2052# avdd pfet_06v0 ad=1.98p pd=7.2u as=1.98p ps=7.2u w=6.6u l=0.6u
X65 bpb bpb bpa_ avdd pfet_06v0 ad=1.98p pd=7.2u as=1.98p ps=7.2u w=6.6u l=0.6u
X66 a_120_2047# a_120_2047# a_252_2220# avdd pfet_06v0 ad=1.98p pd=7.2u as=1.98p ps=7.2u w=6.6u l=0.6u
X67 a_4356_2052# zpp ypm avdd pfet_06v0 ad=1.98p pd=7.2u as=1.98p ps=7.2u w=6.6u l=0.6u
X68 ynp znp a_2484_1344# avss nfet_06v0 ad=1.98p pd=7.2u as=1.98p ps=7.2u w=6.6u l=0.6u
X69 a_n1260_2220# en enb avdd pfet_06v0 ad=1.98p pd=7.2u as=1.98p ps=7.2u w=6.6u l=0.6u
X70 bpa_ bpb bpb avdd pfet_06v0 ad=1.98p pd=7.2u as=1.98p ps=7.2u w=6.6u l=0.6u
X71 a_2316_2220# bpa a_2292_2220# avdd pfet_06v0 ad=1.98p pd=7.2u as=1.98p ps=7.2u w=6.6u l=0.6u
X72 a_4380_2220# zpp a_4356_2220# avdd pfet_06v0 ad=1.98p pd=7.2u as=1.98p ps=7.2u w=6.6u l=0.6u
X73 a_2052_1344# znp avss avss nfet_06v0 ad=1.98p pd=7.2u as=1.98p ps=7.2u w=6.6u l=0.6u
X74 xp0 inp ynm avdd pfet_06v0 ad=1.98p pd=7.2u as=1.98p ps=7.2u w=6.6u l=0.6u
X75 avdd zpm o avdd pfet_06v0 ad=1.98p pd=7.2u as=1.98p ps=7.2u w=6.6u l=0.6u
X76 a_2964_1344# a_n840_1339# zpp avss nfet_06v0 ad=1.98p pd=7.2u as=1.98p ps=7.2u w=6.6u l=0.6u
X77 a_n780_1344# a_n840_1339# a_n840_1339# avss nfet_06v0 ad=1.98p pd=7.2u as=1.98p ps=7.2u w=6.6u l=0.6u
X78 a_2076_1512# znp a_2052_1512# avss nfet_06v0 ad=1.98p pd=7.2u as=1.98p ps=7.2u w=6.6u l=0.6u
X79 a_4836_2220# en avdd avdd pfet_06v0 ad=1.98p pd=7.2u as=1.98p ps=7.2u w=6.6u l=0.6u
X80 avss bna a_468_1512# avss nfet_06v0 ad=1.98p pd=7.2u as=1.98p ps=7.2u w=6.6u l=0.6u
X81 o znm a_4548_1344# avss nfet_06v0 ad=1.98p pd=7.2u as=1.98p ps=7.2u w=6.6u l=0.6u
X82 a_2892_1344# a_n840_1339# a_2964_1512# avss nfet_06v0 ad=1.98p pd=7.2u as=1.98p ps=7.2u w=6.6u l=0.6u
X83 a_4596_1512# znm o avss nfet_06v0 ad=1.98p pd=7.2u as=1.98p ps=7.2u w=6.6u l=0.6u
X84 a_2532_1512# znp ynp avss nfet_06v0 ad=1.98p pd=7.2u as=1.98p ps=7.2u w=6.6u l=0.6u
X85 ypp zpp a_2772_2052# avdd pfet_06v0 ad=1.98p pd=7.2u as=1.98p ps=7.2u w=6.6u l=0.6u
X86 a_4404_2052# zpp a_4380_2052# avdd pfet_06v0 ad=1.98p pd=7.2u as=1.98p ps=7.2u w=6.6u l=0.6u
X87 bpa_ bpb bpb avdd pfet_06v0 ad=1.98p pd=7.2u as=1.98p ps=7.2u w=6.6u l=0.6u
X88 avdd bpa a_2340_2220# avdd pfet_06v0 ad=1.98p pd=7.2u as=1.98p ps=7.2u w=6.6u l=0.6u
X89 a_3420_2052# zpp a_3396_2052# avdd pfet_06v0 ad=1.98p pd=7.2u as=1.98p ps=7.2u w=6.6u l=0.6u
X90 a_4884_2220# en zpm avdd pfet_06v0 ad=1.98p pd=7.2u as=1.98p ps=7.2u w=6.6u l=0.6u
X91 a_2892_1344# a_n840_1339# a_3156_1344# avss nfet_06v0 ad=1.98p pd=7.2u as=1.98p ps=7.2u w=6.6u l=0.6u
X92 a_1116_1344# znp a_1092_1344# avss nfet_06v0 ad=1.98p pd=7.2u as=1.98p ps=7.2u w=6.6u l=0.6u
X93 a_1140_1512# znp a_1116_1512# avss nfet_06v0 ad=1.98p pd=7.2u as=1.98p ps=7.2u w=6.6u l=0.6u
X94 a_3636_1344# znp znm avss nfet_06v0 ad=1.98p pd=7.2u as=1.98p ps=7.2u w=6.6u l=0.6u
X95 ynm znp a_3636_1512# avss nfet_06v0 ad=1.98p pd=7.2u as=1.98p ps=7.2u w=6.6u l=0.6u
X96 a_1860_2052# zpp avdd avdd pfet_06v0 ad=1.98p pd=7.2u as=1.98p ps=7.2u w=6.6u l=0.6u
X97 ypm zpp a_3444_2052# avdd pfet_06v0 ad=1.98p pd=7.2u as=1.98p ps=7.2u w=6.6u l=0.6u
X98 a_1428_2220# zpp a_1404_2220# avdd pfet_06v0 ad=1.98p pd=7.2u as=1.98p ps=7.2u w=6.6u l=0.6u
X99 a_3012_2052# zpp a_2988_2052# avdd pfet_06v0 ad=1.98p pd=7.2u as=1.98p ps=7.2u w=6.6u l=0.6u
X100 a_1164_1344# znp a_1140_1344# avss nfet_06v0 ad=1.98p pd=7.2u as=1.98p ps=7.2u w=6.6u l=0.6u
X101 avdd zpp a_3012_2220# avdd pfet_06v0 ad=1.98p pd=7.2u as=1.98p ps=7.2u w=6.6u l=0.6u
X102 bpb bpb bpa_ avdd pfet_06v0 ad=1.98p pd=7.2u as=1.98p ps=7.2u w=6.6u l=0.6u
X103 a_3924_2052# zpp avdd avdd pfet_06v0 ad=1.98p pd=7.2u as=1.98p ps=7.2u w=6.6u l=0.6u
X104 a_1188_1512# znp a_1164_1512# avss nfet_06v0 ad=1.98p pd=7.2u as=1.98p ps=7.2u w=6.6u l=0.6u
X105 bna enb a_n1212_1344# avss nfet_06v0 ad=1.98p pd=7.2u as=1.98p ps=7.2u w=6.6u l=0.6u
X106 bpa_ bpb bpb avdd pfet_06v0 ad=1.98p pd=7.2u as=1.98p ps=7.2u w=6.6u l=0.6u
X107 a_3948_2220# zpp a_3924_2220# avdd pfet_06v0 ad=1.98p pd=7.2u as=1.98p ps=7.2u w=6.6u l=0.6u
X108 a_3684_1344# znp ynm avss nfet_06v0 ad=1.98p pd=7.2u as=1.98p ps=7.2u w=6.6u l=0.6u
X109 a_n996_2220# bpa a_n1020_2220# avdd pfet_06v0 ad=1.98p pd=7.2u as=1.98p ps=7.2u w=6.6u l=0.6u
X110 a_660_1344# znp a_636_1344# avss nfet_06v0 ad=1.98p pd=7.2u as=1.98p ps=7.2u w=6.6u l=0.6u
X111 znm znp a_3684_1512# avss nfet_06v0 ad=1.98p pd=7.2u as=1.98p ps=7.2u w=6.6u l=0.6u
X112 xn inp a_1620_1512# avss nfet_06v0 ad=1.98p pd=7.2u as=1.98p ps=7.2u w=6.6u l=0.6u
X113 a_1908_2052# zpp a_1884_2052# avdd pfet_06v0 ad=1.98p pd=7.2u as=1.98p ps=7.2u w=6.6u l=0.6u
X114 a_n840_1339# a_n840_1339# a_n540_1344# avss nfet_06v0 ad=1.98p pd=7.2u as=1.98p ps=7.2u w=6.6u l=0.6u
X115 a_3252_1512# bna a_3228_1512# avss nfet_06v0 ad=1.98p pd=7.2u as=1.98p ps=7.2u w=6.6u l=0.6u
X116 a_228_1512# bna a_204_1512# avss nfet_06v0 ad=1.98p pd=7.2u as=1.98p ps=7.2u w=6.6u l=0.6u
X117 avdd zpp a_1428_2052# avdd pfet_06v0 ad=1.98p pd=7.2u as=1.98p ps=7.2u w=6.6u l=0.6u
X118 a_n1212_1512# enb avss avss nfet_06v0 ad=1.98p pd=7.2u as=1.98p ps=7.2u w=6.6u l=0.6u
X119 a_1476_2220# zpp avdd avdd pfet_06v0 ad=1.98p pd=7.2u as=1.98p ps=7.2u w=6.6u l=0.6u
X120 a_3084_2220# zpp a_3060_2220# avdd pfet_06v0 ad=1.98p pd=7.2u as=1.98p ps=7.2u w=6.6u l=0.6u
X121 bpb bpb bpa_ avdd pfet_06v0 ad=1.98p pd=7.2u as=1.98p ps=7.2u w=6.6u l=0.6u
X122 bpb bpb bpa_ avdd pfet_06v0 ad=1.98p pd=7.2u as=1.98p ps=7.2u w=6.6u l=0.6u
X123 a_3972_2052# zpp a_3948_2052# avdd pfet_06v0 ad=1.98p pd=7.2u as=1.98p ps=7.2u w=6.6u l=0.6u
X124 bpa_ bpb bpb avdd pfet_06v0 ad=1.98p pd=7.2u as=1.98p ps=7.2u w=6.6u l=0.6u
X125 ypm zpp a_3972_2220# avdd pfet_06v0 ad=1.98p pd=7.2u as=1.98p ps=7.2u w=6.6u l=0.6u
X126 a_n1020_2052# bpa avdd avdd pfet_06v0 ad=1.98p pd=7.2u as=1.98p ps=7.2u w=6.6u l=0.6u
X127 a_948_2052# bpa a_924_2052# avdd pfet_06v0 ad=1.98p pd=7.2u as=1.98p ps=7.2u w=6.6u l=0.6u
X128 avdd en a_n1068_2220# avdd pfet_06v0 ad=1.98p pd=7.2u as=1.98p ps=7.2u w=6.6u l=0.6u
X129 ypp zpp a_1908_2220# avdd pfet_06v0 ad=1.98p pd=7.2u as=1.98p ps=7.2u w=6.6u l=0.6u
X130 znm bpb zpm avdd pfet_06v0 ad=1.98p pd=7.2u as=1.98p ps=7.2u w=6.6u l=0.6u
X131 a_708_1344# znp ynp avss nfet_06v0 ad=1.98p pd=7.2u as=1.98p ps=7.2u w=6.6u l=0.6u
X132 bpa_ bpb bpb avdd pfet_06v0 ad=1.98p pd=7.2u as=1.98p ps=7.2u w=6.6u l=0.6u
X133 ypm inp a_1668_1512# avss nfet_06v0 ad=1.98p pd=7.2u as=1.98p ps=7.2u w=6.6u l=0.6u
X134 a_252_1344# bna a_228_1344# avss nfet_06v0 ad=1.98p pd=7.2u as=1.98p ps=7.2u w=6.6u l=0.6u
X135 bpb bpb bpa_ avdd pfet_06v0 ad=1.98p pd=7.2u as=1.98p ps=7.2u w=6.6u l=0.6u
X136 a_516_2220# bpa avdd avdd pfet_06v0 ad=1.98p pd=7.2u as=1.98p ps=7.2u w=6.6u l=0.6u
X137 a_2748_1344# bna a_2724_1344# avss nfet_06v0 ad=1.98p pd=7.2u as=1.98p ps=7.2u w=6.6u l=0.6u
X138 bna_ a_n840_1339# a_n588_1344# avss nfet_06v0 ad=1.98p pd=7.2u as=1.98p ps=7.2u w=6.6u l=0.6u
X139 a_n588_1512# a_n840_1339# a_n840_1339# avss nfet_06v0 ad=1.98p pd=7.2u as=1.98p ps=7.2u w=6.6u l=0.6u
X140 a_276_1512# bna a_252_1512# avss nfet_06v0 ad=1.98p pd=7.2u as=1.98p ps=7.2u w=6.6u l=0.6u
X141 a_4356_1344# znp a_4332_1344# avss nfet_06v0 ad=1.98p pd=7.2u as=1.98p ps=7.2u w=6.6u l=0.6u
X142 avdd zpm o avdd pfet_06v0 ad=1.98p pd=7.2u as=1.98p ps=7.2u w=6.6u l=0.6u
X143 a_n1260_1512# en enb avss nfet_06v0 ad=1.98p pd=7.2u as=1.98p ps=7.2u w=6.6u l=0.6u
X144 a_n840_1339# a_n840_1339# a_n156_1512# avss nfet_06v0 ad=1.98p pd=7.2u as=1.98p ps=7.2u w=6.6u l=0.6u
X145 a_732_1512# znp a_708_1512# avss nfet_06v0 ad=1.98p pd=7.2u as=1.98p ps=7.2u w=6.6u l=0.6u
X146 a_4380_1512# znp a_4356_1512# avss nfet_06v0 ad=1.98p pd=7.2u as=1.98p ps=7.2u w=6.6u l=0.6u
X147 ynp znp a_2292_1512# avss nfet_06v0 ad=1.98p pd=7.2u as=1.98p ps=7.2u w=6.6u l=0.6u
X148 znp bpb a_2556_2052# avdd pfet_06v0 ad=1.98p pd=7.2u as=1.98p ps=7.2u w=6.6u l=0.6u
X149 avss znm a_4788_1344# avss nfet_06v0 ad=1.98p pd=7.2u as=1.98p ps=7.2u w=6.6u l=0.6u
X150 ynm inp xp1 avdd pfet_06v0 ad=1.98p pd=7.2u as=1.98p ps=7.2u w=6.6u l=0.6u
X151 a_4836_1512# enb avss avss nfet_06v0 ad=1.98p pd=7.2u as=1.98p ps=7.2u w=6.6u l=0.6u
X152 a_2124_2052# bpa a_2100_2052# avdd pfet_06v0 ad=1.98p pd=7.2u as=1.98p ps=7.2u w=6.6u l=0.6u
X153 znm bpb zpm avdd pfet_06v0 ad=1.98p pd=7.2u as=1.98p ps=7.2u w=6.6u l=0.6u
X154 znp bpb a_2124_2052# avdd pfet_06v0 ad=1.98p pd=7.2u as=1.98p ps=7.2u w=6.6u l=0.6u
X155 bpa_ bpb bpb avdd pfet_06v0 ad=1.98p pd=7.2u as=1.98p ps=7.2u w=6.6u l=0.6u
X156 bpb bpb bpa_ avdd pfet_06v0 ad=1.98p pd=7.2u as=1.98p ps=7.2u w=6.6u l=0.6u
X157 a_564_2220# bpa a_540_2220# avdd pfet_06v0 ad=1.98p pd=7.2u as=1.98p ps=7.2u w=6.6u l=0.6u
X158 o zpm avdd avdd pfet_06v0 ad=1.98p pd=7.2u as=1.98p ps=7.2u w=6.6u l=0.6u
X159 a_2796_1344# bna a_2772_1344# avss nfet_06v0 ad=1.98p pd=7.2u as=1.98p ps=7.2u w=6.6u l=0.6u
X160 a_4404_1344# znp a_4380_1344# avss nfet_06v0 ad=1.98p pd=7.2u as=1.98p ps=7.2u w=6.6u l=0.6u
X161 a_n420_2220# bpa a_n444_2220# avdd pfet_06v0 ad=1.98p pd=7.2u as=1.98p ps=7.2u w=6.6u l=0.6u
X162 avdd zpm o avdd pfet_06v0 ad=1.98p pd=7.2u as=1.98p ps=7.2u w=6.6u l=0.6u
X163 zpm bpb znm avdd pfet_06v0 ad=1.98p pd=7.2u as=1.98p ps=7.2u w=6.6u l=0.6u
X164 bna_ a_n840_1339# a_n204_1512# avss nfet_06v0 ad=1.98p pd=7.2u as=1.98p ps=7.2u w=6.6u l=0.6u
X165 znp znp a_2340_1512# avss nfet_06v0 ad=1.98p pd=7.2u as=1.98p ps=7.2u w=6.6u l=0.6u
X166 a_3420_1344# znp a_3396_1344# avss nfet_06v0 ad=1.98p pd=7.2u as=1.98p ps=7.2u w=6.6u l=0.6u
X167 a_4884_1512# enb znm avss nfet_06v0 ad=1.98p pd=7.2u as=1.98p ps=7.2u w=6.6u l=0.6u
X168 a_2124_2052# bpb znp avdd pfet_06v0 ad=1.98p pd=7.2u as=1.98p ps=7.2u w=6.6u l=0.6u
X169 znp bpb a_2124_2052# avdd pfet_06v0 ad=1.98p pd=7.2u as=1.98p ps=7.2u w=6.6u l=0.6u
X170 o zpm avdd avdd pfet_06v0 ad=1.98p pd=7.2u as=1.98p ps=7.2u w=6.6u l=0.6u
X171 a_60_2052# bpa a_36_2052# avdd pfet_06v0 ad=1.98p pd=7.2u as=1.98p ps=7.2u w=6.6u l=0.6u
X172 a_2652_2220# bpa a_2628_2220# avdd pfet_06v0 ad=1.98p pd=7.2u as=1.98p ps=7.2u w=6.6u l=0.6u
X173 a_1860_1344# bna xn avss nfet_06v0 ad=1.98p pd=7.2u as=1.98p ps=7.2u w=6.6u l=0.6u
X174 a_3468_1344# znp a_3444_1344# avss nfet_06v0 ad=1.98p pd=7.2u as=1.98p ps=7.2u w=6.6u l=0.6u
X175 a_1428_1512# bna a_1404_1512# avss nfet_06v0 ad=1.98p pd=7.2u as=1.98p ps=7.2u w=6.6u l=0.6u
X176 a_3012_1344# a_n840_1339# a_2892_1344# avss nfet_06v0 ad=1.98p pd=7.2u as=1.98p ps=7.2u w=6.6u l=0.6u
X177 a_3924_1344# a_n840_1339# znm avss nfet_06v0 ad=1.98p pd=7.2u as=1.98p ps=7.2u w=6.6u l=0.6u
X178 a_n12_1344# bna a_n36_1344# avss nfet_06v0 ad=1.98p pd=7.2u as=1.98p ps=7.2u w=6.6u l=0.6u
X179 zpp a_n840_1339# a_3012_1512# avss nfet_06v0 ad=1.98p pd=7.2u as=1.98p ps=7.2u w=6.6u l=0.6u
X180 a_n36_1512# bna a_n60_1512# avss nfet_06v0 ad=1.98p pd=7.2u as=1.98p ps=7.2u w=6.6u l=0.6u
X181 zpm a_n840_1339# a_3924_1512# avss nfet_06v0 ad=1.98p pd=7.2u as=1.98p ps=7.2u w=6.6u l=0.6u
X182 avdd bpa a_84_2052# avdd pfet_06v0 ad=1.98p pd=7.2u as=1.98p ps=7.2u w=6.6u l=0.6u
X183 a_1236_2052# bpa a_1212_2052# avdd pfet_06v0 ad=1.98p pd=7.2u as=1.98p ps=7.2u w=6.6u l=0.6u
X184 a_3300_2052# zpp ypp avdd pfet_06v0 ad=1.98p pd=7.2u as=1.98p ps=7.2u w=6.6u l=0.6u
X185 a_n996_1512# bna a_n1020_1512# avss nfet_06v0 ad=1.98p pd=7.2u as=1.98p ps=7.2u w=6.6u l=0.6u
X186 avdd bpa a_1236_2220# avdd pfet_06v0 ad=1.98p pd=7.2u as=1.98p ps=7.2u w=6.6u l=0.6u
X187 ypm zpp zpm avdd pfet_06v0 ad=1.98p pd=7.2u as=1.98p ps=7.2u w=6.6u l=0.6u
X188 a_1908_1344# bna a_1884_1344# avss nfet_06v0 ad=1.98p pd=7.2u as=1.98p ps=7.2u w=6.6u l=0.6u
X189 a_1716_2220# zpp a_1692_2220# avdd pfet_06v0 ad=1.98p pd=7.2u as=1.98p ps=7.2u w=6.6u l=0.6u
X190 zpm zpp ypm avdd pfet_06v0 ad=1.98p pd=7.2u as=1.98p ps=7.2u w=6.6u l=0.6u
X191 xn bna a_1428_1344# avss nfet_06v0 ad=1.98p pd=7.2u as=1.98p ps=7.2u w=6.6u l=0.6u
X192 a_3324_2220# zpp a_3300_2220# avdd pfet_06v0 ad=1.98p pd=7.2u as=1.98p ps=7.2u w=6.6u l=0.6u
X193 a_1476_1512# inm xn avss nfet_06v0 ad=1.98p pd=7.2u as=1.98p ps=7.2u w=6.6u l=0.6u
X194 a_3972_1344# a_n840_1339# zpm avss nfet_06v0 ad=1.98p pd=7.2u as=1.98p ps=7.2u w=6.6u l=0.6u
X195 a_n60_1344# bna bna_ avss nfet_06v0 ad=1.98p pd=7.2u as=1.98p ps=7.2u w=6.6u l=0.6u
X196 a_n348_1344# a_n840_1339# bna_ avss nfet_06v0 ad=1.98p pd=7.2u as=1.98p ps=7.2u w=6.6u l=0.6u
X197 a_2892_1344# a_n840_1339# a_3060_1512# avss nfet_06v0 ad=1.98p pd=7.2u as=1.98p ps=7.2u w=6.6u l=0.6u
X198 bna_ a_n840_1339# a_n108_1512# avss nfet_06v0 ad=1.98p pd=7.2u as=1.98p ps=7.2u w=6.6u l=0.6u
X199 a_948_1344# znp a_924_1344# avss nfet_06v0 ad=1.98p pd=7.2u as=1.98p ps=7.2u w=6.6u l=0.6u
X200 a_n1020_1344# bna avss avss nfet_06v0 ad=1.98p pd=7.2u as=1.98p ps=7.2u w=6.6u l=0.6u
X201 znm a_n840_1339# a_3972_1512# avss nfet_06v0 ad=1.98p pd=7.2u as=1.98p ps=7.2u w=6.6u l=0.6u
X202 a_1284_2052# zpp avdd avdd pfet_06v0 ad=1.98p pd=7.2u as=1.98p ps=7.2u w=6.6u l=0.6u
X203 avss enb a_n1068_1512# avss nfet_06v0 ad=1.98p pd=7.2u as=1.98p ps=7.2u w=6.6u l=0.6u
X204 a_1932_1512# bna a_1908_1512# avss nfet_06v0 ad=1.98p pd=7.2u as=1.98p ps=7.2u w=6.6u l=0.6u
X205 ynm znp a_4116_1344# avss nfet_06v0 ad=1.98p pd=7.2u as=1.98p ps=7.2u w=6.6u l=0.6u
X206 a_1308_2220# zpp a_1284_2220# avdd pfet_06v0 ad=1.98p pd=7.2u as=1.98p ps=7.2u w=6.6u l=0.6u
X207 a_n840_1339# a_n840_1339# a_n828_1344# avss nfet_06v0 ad=1.98p pd=7.2u as=1.98p ps=7.2u w=6.6u l=0.6u
X208 ypm zpp zpm avdd pfet_06v0 ad=1.98p pd=7.2u as=1.98p ps=7.2u w=6.6u l=0.6u
X209 a_n828_1512# a_n840_1339# bna_ avss nfet_06v0 ad=1.98p pd=7.2u as=1.98p ps=7.2u w=6.6u l=0.6u
X210 a_516_1512# znp avss avss nfet_06v0 ad=1.98p pd=7.2u as=1.98p ps=7.2u w=6.6u l=0.6u
X211 xp0 inp ynm avdd pfet_06v0 ad=1.98p pd=7.2u as=1.98p ps=7.2u w=6.6u l=0.6u
X212 a_1764_2220# zpp ypm avdd pfet_06v0 ad=1.98p pd=7.2u as=1.98p ps=7.2u w=6.6u l=0.6u
X213 avss znm a_4596_1512# avss nfet_06v0 ad=1.98p pd=7.2u as=1.98p ps=7.2u w=6.6u l=0.6u
X214 avdd zpp a_3348_2220# avdd pfet_06v0 ad=1.98p pd=7.2u as=1.98p ps=7.2u w=6.6u l=0.6u
X215 bpb bpb bpa_ avdd pfet_06v0 ad=1.98p pd=7.2u as=1.98p ps=7.2u w=6.6u l=0.6u
X216 a_120_2047# a_120_2047# a_300_2052# avdd pfet_06v0 ad=1.98p pd=7.2u as=1.98p ps=7.2u w=6.6u l=0.6u
X217 zpp zpp ypp avdd pfet_06v0 ad=1.98p pd=7.2u as=1.98p ps=7.2u w=6.6u l=0.6u
X218 a_348_2220# a_120_2047# a_120_2047# avdd pfet_06v0 ad=1.98p pd=7.2u as=1.98p ps=7.2u w=6.6u l=0.6u
X219 bnb a_n840_1339# rm3 r_width=0.6u r_length=1.8u
X220 a_2580_1344# znp a_2556_1344# avss nfet_06v0 ad=1.98p pd=7.2u as=1.98p ps=7.2u w=6.6u l=0.6u
X221 avdd zpp a_4404_2052# avdd pfet_06v0 ad=1.98p pd=7.2u as=1.98p ps=7.2u w=6.6u l=0.6u
X222 a_996_1344# znp a_972_1344# avss nfet_06v0 ad=1.98p pd=7.2u as=1.98p ps=7.2u w=6.6u l=0.6u
X223 bpb bpb bpa_ avdd pfet_06v0 ad=1.98p pd=7.2u as=1.98p ps=7.2u w=6.6u l=0.6u
X224 znm znp a_4164_1344# avss nfet_06v0 ad=1.98p pd=7.2u as=1.98p ps=7.2u w=6.6u l=0.6u
X225 a_2124_1344# znp a_2100_1344# avss nfet_06v0 ad=1.98p pd=7.2u as=1.98p ps=7.2u w=6.6u l=0.6u
X226 bna_ bna a_n876_1344# avss nfet_06v0 ad=1.98p pd=7.2u as=1.98p ps=7.2u w=6.6u l=0.6u
X227 a_2148_1512# znp a_2124_1512# avss nfet_06v0 ad=1.98p pd=7.2u as=1.98p ps=7.2u w=6.6u l=0.6u
X228 a_n876_1512# bna a_n900_1512# avss nfet_06v0 ad=1.98p pd=7.2u as=1.98p ps=7.2u w=6.6u l=0.6u
X229 a_564_1512# znp a_540_1512# avss nfet_06v0 ad=1.98p pd=7.2u as=1.98p ps=7.2u w=6.6u l=0.6u
X230 a_4644_1344# znm avss avss nfet_06v0 ad=1.98p pd=7.2u as=1.98p ps=7.2u w=6.6u l=0.6u
X231 a_n840_1339# a_n840_1339# a_n444_1512# avss nfet_06v0 ad=1.98p pd=7.2u as=1.98p ps=7.2u w=6.6u l=0.6u
X232 o znm a_4644_1512# avss nfet_06v0 ad=1.98p pd=7.2u as=1.98p ps=7.2u w=6.6u l=0.6u
X233 bpb bpb bpa_ avdd pfet_06v0 ad=1.98p pd=7.2u as=1.98p ps=7.2u w=6.6u l=0.6u
X234 a_120_2047# a_120_2047# a_348_2052# avdd pfet_06v0 ad=1.98p pd=7.2u as=1.98p ps=7.2u w=6.6u l=0.6u
X235 zpp zpp ypp avdd pfet_06v0 ad=1.98p pd=7.2u as=1.98p ps=7.2u w=6.6u l=0.6u
X236 a_4212_1512# znp znm avss nfet_06v0 ad=1.98p pd=7.2u as=1.98p ps=7.2u w=6.6u l=0.6u
X237 a_396_2220# a_120_2047# a_120_2047# avdd pfet_06v0 ad=1.98p pd=7.2u as=1.98p ps=7.2u w=6.6u l=0.6u
X238 a_2412_2052# bpa a_2388_2052# avdd pfet_06v0 ad=1.98p pd=7.2u as=1.98p ps=7.2u w=6.6u l=0.6u
X239 avdd zpm o avdd pfet_06v0 ad=1.98p pd=7.2u as=1.98p ps=7.2u w=6.6u l=0.6u
X240 bpb bpb bpa_ avdd pfet_06v0 ad=1.98p pd=7.2u as=1.98p ps=7.2u w=6.6u l=0.6u
X241 a_2436_2220# bpa a_2412_2220# avdd pfet_06v0 ad=1.98p pd=7.2u as=1.98p ps=7.2u w=6.6u l=0.6u
X242 o zpm avdd avdd pfet_06v0 ad=1.98p pd=7.2u as=1.98p ps=7.2u w=6.6u l=0.6u
X243 a_2172_1344# znp a_2148_1344# avss nfet_06v0 ad=1.98p pd=7.2u as=1.98p ps=7.2u w=6.6u l=0.6u
X244 a_852_2220# bpa a_828_2220# avdd pfet_06v0 ad=1.98p pd=7.2u as=1.98p ps=7.2u w=6.6u l=0.6u
X245 ypm zpp zpm avdd pfet_06v0 ad=1.98p pd=7.2u as=1.98p ps=7.2u w=6.6u l=0.6u
X246 a_2196_1512# znp a_2172_1512# avss nfet_06v0 ad=1.98p pd=7.2u as=1.98p ps=7.2u w=6.6u l=0.6u
X247 a_4692_1344# znm o avss nfet_06v0 ad=1.98p pd=7.2u as=1.98p ps=7.2u w=6.6u l=0.6u
X248 a_60_1344# bna a_36_1344# avss nfet_06v0 ad=1.98p pd=7.2u as=1.98p ps=7.2u w=6.6u l=0.6u
X249 a_2652_1512# znp a_2628_1512# avss nfet_06v0 ad=1.98p pd=7.2u as=1.98p ps=7.2u w=6.6u l=0.6u
X250 xp1 inp ynm avdd pfet_06v0 ad=1.98p pd=7.2u as=1.98p ps=7.2u w=6.6u l=0.6u
X251 znp bpb a_2460_2052# avdd pfet_06v0 ad=1.98p pd=7.2u as=1.98p ps=7.2u w=6.6u l=0.6u
X252 znm bpb zpm avdd pfet_06v0 ad=1.98p pd=7.2u as=1.98p ps=7.2u w=6.6u l=0.6u
X253 zpm zpp ypm avdd pfet_06v0 ad=1.98p pd=7.2u as=1.98p ps=7.2u w=6.6u l=0.6u
X254 a_3300_1344# bna a_3276_1344# avss nfet_06v0 ad=1.98p pd=7.2u as=1.98p ps=7.2u w=6.6u l=0.6u
X255 a_1236_1344# znp a_1212_1344# avss nfet_06v0 ad=1.98p pd=7.2u as=1.98p ps=7.2u w=6.6u l=0.6u
X256 avss bna a_84_1344# avss nfet_06v0 ad=1.98p pd=7.2u as=1.98p ps=7.2u w=6.6u l=0.6u
X257 avss znp a_1236_1512# avss nfet_06v0 ad=1.98p pd=7.2u as=1.98p ps=7.2u w=6.6u l=0.6u
X258 zpm a_n840_1339# a_3732_1344# avss nfet_06v0 ad=1.98p pd=7.2u as=1.98p ps=7.2u w=6.6u l=0.6u
X259 xp1 inp ynm avdd pfet_06v0 ad=1.98p pd=7.2u as=1.98p ps=7.2u w=6.6u l=0.6u
X260 a_1716_1512# inp ypm avss nfet_06v0 ad=1.98p pd=7.2u as=1.98p ps=7.2u w=6.6u l=0.6u
X261 a_3780_1512# a_n840_1339# zpm avss nfet_06v0 ad=1.98p pd=7.2u as=1.98p ps=7.2u w=6.6u l=0.6u
X262 a_1980_2052# zpp a_1956_2052# avdd pfet_06v0 ad=1.98p pd=7.2u as=1.98p ps=7.2u w=6.6u l=0.6u
X263 a_3324_1512# bna a_3300_1512# avss nfet_06v0 ad=1.98p pd=7.2u as=1.98p ps=7.2u w=6.6u l=0.6u
X264 a_1524_2052# zpp a_1500_2052# avdd pfet_06v0 ad=1.98p pd=7.2u as=1.98p ps=7.2u w=6.6u l=0.6u
X265 zpm bpb znm avdd pfet_06v0 ad=1.98p pd=7.2u as=1.98p ps=7.2u w=6.6u l=0.6u
X266 ypm zpp a_1524_2220# avdd pfet_06v0 ad=1.98p pd=7.2u as=1.98p ps=7.2u w=6.6u l=0.6u
X267 ypp zpp a_3108_2052# avdd pfet_06v0 ad=1.98p pd=7.2u as=1.98p ps=7.2u w=6.6u l=0.6u
X268 a_1284_1344# bna avss avss nfet_06v0 ad=1.98p pd=7.2u as=1.98p ps=7.2u w=6.6u l=0.6u
X269 zpp zpp ypp avdd pfet_06v0 ad=1.98p pd=7.2u as=1.98p ps=7.2u w=6.6u l=0.6u
X270 a_1308_1512# bna a_1284_1512# avss nfet_06v0 ad=1.98p pd=7.2u as=1.98p ps=7.2u w=6.6u l=0.6u
X271 bpa enb a_n1116_2052# avdd pfet_06v0 ad=1.98p pd=7.2u as=1.98p ps=7.2u w=6.6u l=0.6u
X272 znm a_n840_1339# a_3780_1344# avss nfet_06v0 ad=1.98p pd=7.2u as=1.98p ps=7.2u w=6.6u l=0.6u
X273 a_n1116_2220# enb bpa_ avdd pfet_06v0 ad=1.98p pd=7.2u as=1.98p ps=7.2u w=6.6u l=0.6u
X274 a_780_1344# znp a_756_1344# avss nfet_06v0 ad=1.98p pd=7.2u as=1.98p ps=7.2u w=6.6u l=0.6u
X275 znm bpb zpm avdd pfet_06v0 ad=1.98p pd=7.2u as=1.98p ps=7.2u w=6.6u l=0.6u
X276 a_1764_1512# inm xn avss nfet_06v0 ad=1.98p pd=7.2u as=1.98p ps=7.2u w=6.6u l=0.6u
X277 a_2820_1344# bna a_2796_1344# avss nfet_06v0 ad=1.98p pd=7.2u as=1.98p ps=7.2u w=6.6u l=0.6u
X278 a_324_1344# bna bpb avss nfet_06v0 ad=1.98p pd=7.2u as=1.98p ps=7.2u w=6.6u l=0.6u
X279 a_n636_1344# a_n840_1339# bna_ avss nfet_06v0 ad=1.98p pd=7.2u as=1.98p ps=7.2u w=6.6u l=0.6u
X280 avss bna a_3348_1512# avss nfet_06v0 ad=1.98p pd=7.2u as=1.98p ps=7.2u w=6.6u l=0.6u
X281 a_348_1512# bna a_324_1512# avss nfet_06v0 ad=1.98p pd=7.2u as=1.98p ps=7.2u w=6.6u l=0.6u
X282 avss znp a_4404_1344# avss nfet_06v0 ad=1.98p pd=7.2u as=1.98p ps=7.2u w=6.6u l=0.6u
X283 a_1572_2052# zpp ypm avdd pfet_06v0 ad=1.98p pd=7.2u as=1.98p ps=7.2u w=6.6u l=0.6u
X284 a_1596_2220# zpp a_1572_2220# avdd pfet_06v0 ad=1.98p pd=7.2u as=1.98p ps=7.2u w=6.6u l=0.6u
X285 a_n204_1512# a_n840_1339# a_n840_1339# avss nfet_06v0 ad=1.98p pd=7.2u as=1.98p ps=7.2u w=6.6u l=0.6u
X286 avdd bpa a_n492_2052# avdd pfet_06v0 ad=1.98p pd=7.2u as=1.98p ps=7.2u w=6.6u l=0.6u
X287 a_156_2052# a_120_2047# a_120_2047# avdd pfet_06v0 ad=1.98p pd=7.2u as=1.98p ps=7.2u w=6.6u l=0.6u
X288 a_120_2047# a_120_2047# a_156_2220# avdd pfet_06v0 ad=1.98p pd=7.2u as=1.98p ps=7.2u w=6.6u l=0.6u
X289 zpp zpp ypp avdd pfet_06v0 ad=1.98p pd=7.2u as=1.98p ps=7.2u w=6.6u l=0.6u
X290 bpa_ enb a_n1164_2052# avdd pfet_06v0 ad=1.98p pd=7.2u as=1.98p ps=7.2u w=6.6u l=0.6u
X291 a_n1164_2220# enb bpa avdd pfet_06v0 ad=1.98p pd=7.2u as=1.98p ps=7.2u w=6.6u l=0.6u
X292 zpm bpb znm avdd pfet_06v0 ad=1.98p pd=7.2u as=1.98p ps=7.2u w=6.6u l=0.6u
X293 a_2220_2052# bpb znp avdd pfet_06v0 ad=1.98p pd=7.2u as=1.98p ps=7.2u w=6.6u l=0.6u
X294 bpb bpb bpa_ avdd pfet_06v0 ad=1.98p pd=7.2u as=1.98p ps=7.2u w=6.6u l=0.6u
X295 ynp inm xp0 avdd pfet_06v0 ad=1.98p pd=7.2u as=1.98p ps=7.2u w=6.6u l=0.6u
X296 bpa_ bpa a_n972_2220# avdd pfet_06v0 ad=1.98p pd=7.2u as=1.98p ps=7.2u w=6.6u l=0.6u
X297 xp0 inm ynp avdd pfet_06v0 ad=1.98p pd=7.2u as=1.98p ps=7.2u w=6.6u l=0.6u
X298 a_2868_1344# bna a_2844_1344# avss nfet_06v0 ad=1.98p pd=7.2u as=1.98p ps=7.2u w=6.6u l=0.6u
X299 a_372_1344# bna a_348_1344# avss nfet_06v0 ad=1.98p pd=7.2u as=1.98p ps=7.2u w=6.6u l=0.6u
X300 a_n684_1344# a_n840_1339# a_n840_1339# avss nfet_06v0 ad=1.98p pd=7.2u as=1.98p ps=7.2u w=6.6u l=0.6u
X301 avdd zpm o avdd pfet_06v0 ad=1.98p pd=7.2u as=1.98p ps=7.2u w=6.6u l=0.6u
X302 a_396_1512# bna a_372_1512# avss nfet_06v0 ad=1.98p pd=7.2u as=1.98p ps=7.2u w=6.6u l=0.6u
X303 a_n492_2220# bpa a_n516_2220# avdd pfet_06v0 ad=1.98p pd=7.2u as=1.98p ps=7.2u w=6.6u l=0.6u
X304 o zpm avdd avdd pfet_06v0 ad=1.98p pd=7.2u as=1.98p ps=7.2u w=6.6u l=0.6u
X305 o znm a_4452_1344# avss nfet_06v0 ad=1.98p pd=7.2u as=1.98p ps=7.2u w=6.6u l=0.6u
X306 ynp znp a_2388_1344# avss nfet_06v0 ad=1.98p pd=7.2u as=1.98p ps=7.2u w=6.6u l=0.6u
X307 a_n252_1512# a_n840_1339# bna_ avss nfet_06v0 ad=1.98p pd=7.2u as=1.98p ps=7.2u w=6.6u l=0.6u
X308 a_4500_1512# znm o avss nfet_06v0 ad=1.98p pd=7.2u as=1.98p ps=7.2u w=6.6u l=0.6u
X309 a_2436_1512# znp ynp avss nfet_06v0 ad=1.98p pd=7.2u as=1.98p ps=7.2u w=6.6u l=0.6u
X310 a_204_2052# a_120_2047# a_120_2047# avdd pfet_06v0 ad=1.98p pd=7.2u as=1.98p ps=7.2u w=6.6u l=0.6u
X311 a_852_1512# znp a_828_1512# avss nfet_06v0 ad=1.98p pd=7.2u as=1.98p ps=7.2u w=6.6u l=0.6u
X312 zpm a_n840_1339# a_4020_1512# avss nfet_06v0 ad=1.98p pd=7.2u as=1.98p ps=7.2u w=6.6u l=0.6u
X313 avdd bpa a_2676_2052# avdd pfet_06v0 ad=1.98p pd=7.2u as=1.98p ps=7.2u w=6.6u l=0.6u
X314 znp bpb a_2220_2052# avdd pfet_06v0 ad=1.98p pd=7.2u as=1.98p ps=7.2u w=6.6u l=0.6u
X315 zpm zpp ypm avdd pfet_06v0 ad=1.98p pd=7.2u as=1.98p ps=7.2u w=6.6u l=0.6u
X316 a_2220_2052# bpb znp avdd pfet_06v0 ad=1.98p pd=7.2u as=1.98p ps=7.2u w=6.6u l=0.6u
X317 a_n972_2052# bpa a_n996_2052# avdd pfet_06v0 ad=1.98p pd=7.2u as=1.98p ps=7.2u w=6.6u l=0.6u
X318 xp0 inm ynp avdd pfet_06v0 ad=1.98p pd=7.2u as=1.98p ps=7.2u w=6.6u l=0.6u
X319 avdd zpm o avdd pfet_06v0 ad=1.98p pd=7.2u as=1.98p ps=7.2u w=6.6u l=0.6u
X320 a_n540_2220# bpa bpa_ avdd pfet_06v0 ad=1.98p pd=7.2u as=1.98p ps=7.2u w=6.6u l=0.6u
X321 a_2724_2220# zpp avdd avdd pfet_06v0 ad=1.98p pd=7.2u as=1.98p ps=7.2u w=6.6u l=0.6u
X322 o zpm avdd avdd pfet_06v0 ad=1.98p pd=7.2u as=1.98p ps=7.2u w=6.6u l=0.6u
X323 a_1020_1344# znp a_996_1344# avss nfet_06v0 ad=1.98p pd=7.2u as=1.98p ps=7.2u w=6.6u l=0.6u
X324 ypm zpp zpm avdd pfet_06v0 ad=1.98p pd=7.2u as=1.98p ps=7.2u w=6.6u l=0.6u
X325 a_2484_1512# znp znp avss nfet_06v0 ad=1.98p pd=7.2u as=1.98p ps=7.2u w=6.6u l=0.6u
X326 a_3540_1344# znp a_3516_1344# avss nfet_06v0 ad=1.98p pd=7.2u as=1.98p ps=7.2u w=6.6u l=0.6u
X327 znm a_n840_1339# a_4068_1512# avss nfet_06v0 ad=1.98p pd=7.2u as=1.98p ps=7.2u w=6.6u l=0.6u
X328 a_2292_2052# bpa a_2220_2052# avdd pfet_06v0 ad=1.98p pd=7.2u as=1.98p ps=7.2u w=6.6u l=0.6u
X329 a_2772_2220# zpp a_2748_2220# avdd pfet_06v0 ad=1.98p pd=7.2u as=1.98p ps=7.2u w=6.6u l=0.6u
X330 ynm znp a_1044_1344# avss nfet_06v0 ad=1.98p pd=7.2u as=1.98p ps=7.2u w=6.6u l=0.6u
X331 a_1980_1344# bna a_1956_1344# avss nfet_06v0 ad=1.98p pd=7.2u as=1.98p ps=7.2u w=6.6u l=0.6u
X332 a_3828_2052# zpp ypm avdd pfet_06v0 ad=1.98p pd=7.2u as=1.98p ps=7.2u w=6.6u l=0.6u
X333 a_3588_1344# znp ynm avss nfet_06v0 ad=1.98p pd=7.2u as=1.98p ps=7.2u w=6.6u l=0.6u
X334 a_1524_1344# inm ypp avss nfet_06v0 ad=1.98p pd=7.2u as=1.98p ps=7.2u w=6.6u l=0.6u
X335 xn inm a_1524_1512# avss nfet_06v0 ad=1.98p pd=7.2u as=1.98p ps=7.2u w=6.6u l=0.6u
X336 zpp a_n840_1339# a_3108_1344# avss nfet_06v0 ad=1.98p pd=7.2u as=1.98p ps=7.2u w=6.6u l=0.6u
X337 a_3156_1512# a_n840_1339# zpp avss nfet_06v0 ad=1.98p pd=7.2u as=1.98p ps=7.2u w=6.6u l=0.6u
X338 bna en a_n1116_1344# avss nfet_06v0 ad=1.98p pd=7.2u as=1.98p ps=7.2u w=6.6u l=0.6u
X339 ypp zpp a_1332_2052# avdd pfet_06v0 ad=1.98p pd=7.2u as=1.98p ps=7.2u w=6.6u l=0.6u
X340 a_n1116_1512# en bna_ avss nfet_06v0 ad=1.98p pd=7.2u as=1.98p ps=7.2u w=6.6u l=0.6u
X341 a_1380_2220# zpp ypp avdd pfet_06v0 ad=1.98p pd=7.2u as=1.98p ps=7.2u w=6.6u l=0.6u
X342 znm znp a_3588_1512# avss nfet_06v0 ad=1.98p pd=7.2u as=1.98p ps=7.2u w=6.6u l=0.6u
X343 a_1812_2052# zpp a_1788_2052# avdd pfet_06v0 ad=1.98p pd=7.2u as=1.98p ps=7.2u w=6.6u l=0.6u
X344 a_3876_2052# zpp a_3852_2052# avdd pfet_06v0 ad=1.98p pd=7.2u as=1.98p ps=7.2u w=6.6u l=0.6u
X345 avdd zpp a_1812_2220# avdd pfet_06v0 ad=1.98p pd=7.2u as=1.98p ps=7.2u w=6.6u l=0.6u
X346 avdd zpp a_3876_2220# avdd pfet_06v0 ad=1.98p pd=7.2u as=1.98p ps=7.2u w=6.6u l=0.6u
X347 a_1572_1344# inp xn avss nfet_06v0 ad=1.98p pd=7.2u as=1.98p ps=7.2u w=6.6u l=0.6u
X348 a_3444_2220# zpp a_3420_2220# avdd pfet_06v0 ad=1.98p pd=7.2u as=1.98p ps=7.2u w=6.6u l=0.6u
X349 bpa_ bpb bpb avdd pfet_06v0 ad=1.98p pd=7.2u as=1.98p ps=7.2u w=6.6u l=0.6u
X350 ypm inp a_1572_1512# avss nfet_06v0 ad=1.98p pd=7.2u as=1.98p ps=7.2u w=6.6u l=0.6u
X351 a_120_2047# a_120_2047# a_396_2220# avdd pfet_06v0 ad=1.98p pd=7.2u as=1.98p ps=7.2u w=6.6u l=0.6u
X352 a_156_1344# bna a_132_1344# avss nfet_06v0 ad=1.98p pd=7.2u as=1.98p ps=7.2u w=6.6u l=0.6u
X353 bna_ a_n840_1339# a_n492_1344# avss nfet_06v0 ad=1.98p pd=7.2u as=1.98p ps=7.2u w=6.6u l=0.6u
X354 a_3204_1512# bna a_2892_1344# avss nfet_06v0 ad=1.98p pd=7.2u as=1.98p ps=7.2u w=6.6u l=0.6u
X355 a_180_1512# bna a_156_1512# avss nfet_06v0 ad=1.98p pd=7.2u as=1.98p ps=7.2u w=6.6u l=0.6u
X356 bna_ en a_n1164_1344# avss nfet_06v0 ad=1.98p pd=7.2u as=1.98p ps=7.2u w=6.6u l=0.6u
X357 a_1404_2052# zpp a_1380_2052# avdd pfet_06v0 ad=1.98p pd=7.2u as=1.98p ps=7.2u w=6.6u l=0.6u
X358 a_n1164_1512# en bna avss nfet_06v0 ad=1.98p pd=7.2u as=1.98p ps=7.2u w=6.6u l=0.6u
X359 a_4260_1344# znp ynm avss nfet_06v0 ad=1.98p pd=7.2u as=1.98p ps=7.2u w=6.6u l=0.6u
X360 a_612_1344# znp a_588_1344# avss nfet_06v0 ad=1.98p pd=7.2u as=1.98p ps=7.2u w=6.6u l=0.6u
X361 a_n924_1344# bna a_n948_1344# avss nfet_06v0 ad=1.98p pd=7.2u as=1.98p ps=7.2u w=6.6u l=0.6u
X362 ynp znp a_2196_1512# avss nfet_06v0 ad=1.98p pd=7.2u as=1.98p ps=7.2u w=6.6u l=0.6u
X363 a_n948_1512# bna a_n972_1512# avss nfet_06v0 ad=1.98p pd=7.2u as=1.98p ps=7.2u w=6.6u l=0.6u
X364 a_636_1512# znp a_612_1512# avss nfet_06v0 ad=1.98p pd=7.2u as=1.98p ps=7.2u w=6.6u l=0.6u
X365 avss znm a_4692_1344# avss nfet_06v0 ad=1.98p pd=7.2u as=1.98p ps=7.2u w=6.6u l=0.6u
X366 a_900_2052# bpa avdd avdd pfet_06v0 ad=1.98p pd=7.2u as=1.98p ps=7.2u w=6.6u l=0.6u
X367 a_1884_2220# zpp a_1860_2220# avdd pfet_06v0 ad=1.98p pd=7.2u as=1.98p ps=7.2u w=6.6u l=0.6u
X368 avdd zpp a_2004_2052# avdd pfet_06v0 ad=1.98p pd=7.2u as=1.98p ps=7.2u w=6.6u l=0.6u
X369 a_n492_1512# a_n840_1339# a_n840_1339# avss nfet_06v0 ad=1.98p pd=7.2u as=1.98p ps=7.2u w=6.6u l=0.6u
X370 a_4740_1512# znm avss avss nfet_06v0 ad=1.98p pd=7.2u as=1.98p ps=7.2u w=6.6u l=0.6u
X371 zpm zpp ypm avdd pfet_06v0 ad=1.98p pd=7.2u as=1.98p ps=7.2u w=6.6u l=0.6u
X372 bpa_ bpb bpb avdd pfet_06v0 ad=1.98p pd=7.2u as=1.98p ps=7.2u w=6.6u l=0.6u
X373 a_444_2052# a_120_2047# a_120_2047# avdd pfet_06v0 ad=1.98p pd=7.2u as=1.98p ps=7.2u w=6.6u l=0.6u
X374 a_120_2047# a_120_2047# a_444_2220# avdd pfet_06v0 ad=1.98p pd=7.2u as=1.98p ps=7.2u w=6.6u l=0.6u
X375 ypp zpp zpp avdd pfet_06v0 ad=1.98p pd=7.2u as=1.98p ps=7.2u w=6.6u l=0.6u
X376 avss znp a_2676_1344# avss nfet_06v0 ad=1.98p pd=7.2u as=1.98p ps=7.2u w=6.6u l=0.6u
X377 a_204_1344# bna a_180_1344# avss nfet_06v0 ad=1.98p pd=7.2u as=1.98p ps=7.2u w=6.6u l=0.6u
X378 bpb bpb bpa_ avdd pfet_06v0 ad=1.98p pd=7.2u as=1.98p ps=7.2u w=6.6u l=0.6u
X379 o zpm avdd avdd pfet_06v0 ad=1.98p pd=7.2u as=1.98p ps=7.2u w=6.6u l=0.6u
X380 bpa_ bpb bpb avdd pfet_06v0 ad=1.98p pd=7.2u as=1.98p ps=7.2u w=6.6u l=0.6u
X381 a_4308_1344# znp a_4284_1344# avss nfet_06v0 ad=1.98p pd=7.2u as=1.98p ps=7.2u w=6.6u l=0.6u
X382 a_2244_1344# znp ynp avss nfet_06v0 ad=1.98p pd=7.2u as=1.98p ps=7.2u w=6.6u l=0.6u
X383 a_924_2220# bpa a_900_2220# avdd pfet_06v0 ad=1.98p pd=7.2u as=1.98p ps=7.2u w=6.6u l=0.6u
X384 a_n972_1344# bna a_n996_1344# avss nfet_06v0 ad=1.98p pd=7.2u as=1.98p ps=7.2u w=6.6u l=0.6u
X385 znp znp a_2244_1512# avss nfet_06v0 ad=1.98p pd=7.2u as=1.98p ps=7.2u w=6.6u l=0.6u
X386 zpm bpb znm avdd pfet_06v0 ad=1.98p pd=7.2u as=1.98p ps=7.2u w=6.6u l=0.6u
X387 ynp znp a_660_1512# avss nfet_06v0 ad=1.98p pd=7.2u as=1.98p ps=7.2u w=6.6u l=0.6u
X388 o znm a_4740_1344# avss nfet_06v0 ad=1.98p pd=7.2u as=1.98p ps=7.2u w=6.6u l=0.6u
X389 a_2076_2052# bpa a_2052_2052# avdd pfet_06v0 ad=1.98p pd=7.2u as=1.98p ps=7.2u w=6.6u l=0.6u
X390 a_n540_1512# a_n840_1339# bna_ avss nfet_06v0 ad=1.98p pd=7.2u as=1.98p ps=7.2u w=6.6u l=0.6u
X391 a_4788_1512# znm o avss nfet_06v0 ad=1.98p pd=7.2u as=1.98p ps=7.2u w=6.6u l=0.6u
X392 a_2724_1512# bna avss avss nfet_06v0 ad=1.98p pd=7.2u as=1.98p ps=7.2u w=6.6u l=0.6u
X393 avdd a_120_2047# a_120_2047# avdd pfet_06v0 ad=1.98p pd=7.2u as=1.98p ps=7.2u w=6.6u l=0.6u
X394 a_4332_1512# znp a_4308_1512# avss nfet_06v0 ad=1.98p pd=7.2u as=1.98p ps=7.2u w=6.6u l=0.6u
X395 a_2100_2220# bpa a_2076_2220# avdd pfet_06v0 ad=1.98p pd=7.2u as=1.98p ps=7.2u w=6.6u l=0.6u
X396 a_2988_2052# zpp a_2964_2052# avdd pfet_06v0 ad=1.98p pd=7.2u as=1.98p ps=7.2u w=6.6u l=0.6u
X397 znp bpb a_2460_2052# avdd pfet_06v0 ad=1.98p pd=7.2u as=1.98p ps=7.2u w=6.6u l=0.6u
X398 o zpm avdd avdd pfet_06v0 ad=1.98p pd=7.2u as=1.98p ps=7.2u w=6.6u l=0.6u
X399 bpa_ bpa a_n396_2220# avdd pfet_06v0 ad=1.98p pd=7.2u as=1.98p ps=7.2u w=6.6u l=0.6u
X400 a_2556_2052# bpb znp avdd pfet_06v0 ad=1.98p pd=7.2u as=1.98p ps=7.2u w=6.6u l=0.6u
X401 a_2292_1344# znp znp avss nfet_06v0 ad=1.98p pd=7.2u as=1.98p ps=7.2u w=6.6u l=0.6u
X402 xp1 bpa a_948_2220# avdd pfet_06v0 ad=1.98p pd=7.2u as=1.98p ps=7.2u w=6.6u l=0.6u
X403 zpm bpb znm avdd pfet_06v0 ad=1.98p pd=7.2u as=1.98p ps=7.2u w=6.6u l=0.6u
X404 a_2772_1512# bna a_2748_1512# avss nfet_06v0 ad=1.98p pd=7.2u as=1.98p ps=7.2u w=6.6u l=0.6u
X405 bpa_ bpb bpb avdd pfet_06v0 ad=1.98p pd=7.2u as=1.98p ps=7.2u w=6.6u l=0.6u
X406 a_3828_1344# a_n840_1339# znm avss nfet_06v0 ad=1.98p pd=7.2u as=1.98p ps=7.2u w=6.6u l=0.6u
X407 ynp inm xp1 avdd pfet_06v0 ad=1.98p pd=7.2u as=1.98p ps=7.2u w=6.6u l=0.6u
X408 a_2556_2052# bpb znp avdd pfet_06v0 ad=1.98p pd=7.2u as=1.98p ps=7.2u w=6.6u l=0.6u
X409 znm bpb zpm avdd pfet_06v0 ad=1.98p pd=7.2u as=1.98p ps=7.2u w=6.6u l=0.6u
X410 a_1620_2220# zpp a_1596_2220# avdd pfet_06v0 ad=1.98p pd=7.2u as=1.98p ps=7.2u w=6.6u l=0.6u
X411 a_1356_1344# bna a_1332_1344# avss nfet_06v0 ad=1.98p pd=7.2u as=1.98p ps=7.2u w=6.6u l=0.6u
X412 a_1380_1512# bna a_1356_1512# avss nfet_06v0 ad=1.98p pd=7.2u as=1.98p ps=7.2u w=6.6u l=0.6u
X413 a_36_2220# bpa bpa_ avdd pfet_06v0 ad=1.98p pd=7.2u as=1.98p ps=7.2u w=6.6u l=0.6u
X414 ypp zpp zpp avdd pfet_06v0 ad=1.98p pd=7.2u as=1.98p ps=7.2u w=6.6u l=0.6u
X415 a_3876_1344# a_n840_1339# zpm avss nfet_06v0 ad=1.98p pd=7.2u as=1.98p ps=7.2u w=6.6u l=0.6u
X416 a_1812_1344# inm ypp avss nfet_06v0 ad=1.98p pd=7.2u as=1.98p ps=7.2u w=6.6u l=0.6u
X417 a_1188_2052# bpa xp1 avdd pfet_06v0 ad=1.98p pd=7.2u as=1.98p ps=7.2u w=6.6u l=0.6u
X418 xn inm a_1812_1512# avss nfet_06v0 ad=1.98p pd=7.2u as=1.98p ps=7.2u w=6.6u l=0.6u
X419 znm a_n840_1339# a_3876_1512# avss nfet_06v0 ad=1.98p pd=7.2u as=1.98p ps=7.2u w=6.6u l=0.6u
X420 a_n840_1339# a_n840_1339# a_n732_1344# avss nfet_06v0 ad=1.98p pd=7.2u as=1.98p ps=7.2u w=6.6u l=0.6u
X421 a_3444_1512# znp a_3420_1512# avss nfet_06v0 ad=1.98p pd=7.2u as=1.98p ps=7.2u w=6.6u l=0.6u
X422 a_420_1512# bna a_396_1512# avss nfet_06v0 ad=1.98p pd=7.2u as=1.98p ps=7.2u w=6.6u l=0.6u
X423 avdd zpp a_1620_2052# avdd pfet_06v0 ad=1.98p pd=7.2u as=1.98p ps=7.2u w=6.6u l=0.6u
X424 znm bpb zpm avdd pfet_06v0 ad=1.98p pd=7.2u as=1.98p ps=7.2u w=6.6u l=0.6u
X425 a_1668_2220# zpp avdd avdd pfet_06v0 ad=1.98p pd=7.2u as=1.98p ps=7.2u w=6.6u l=0.6u
X426 zpp zpp ypp avdd pfet_06v0 ad=1.98p pd=7.2u as=1.98p ps=7.2u w=6.6u l=0.6u
X427 a_1404_1344# bna a_1380_1344# avss nfet_06v0 ad=1.98p pd=7.2u as=1.98p ps=7.2u w=6.6u l=0.6u
X428 a_120_2047# a_120_2047# a_204_2052# avdd pfet_06v0 ad=1.98p pd=7.2u as=1.98p ps=7.2u w=6.6u l=0.6u
X429 a_84_2220# bpa a_60_2220# avdd pfet_06v0 ad=1.98p pd=7.2u as=1.98p ps=7.2u w=6.6u l=0.6u
X430 a_1212_2220# bpa a_1188_2220# avdd pfet_06v0 ad=1.98p pd=7.2u as=1.98p ps=7.2u w=6.6u l=0.6u
X431 ypp zpp zpp avdd pfet_06v0 ad=1.98p pd=7.2u as=1.98p ps=7.2u w=6.6u l=0.6u
X432 a_n1212_2052# en avdd avdd pfet_06v0 ad=1.98p pd=7.2u as=1.98p ps=7.2u w=6.6u l=0.6u
X433 a_900_1344# znp avss avss nfet_06v0 ad=1.98p pd=7.2u as=1.98p ps=7.2u w=6.6u l=0.6u
X434 avdd en a_n1260_2220# avdd pfet_06v0 ad=1.98p pd=7.2u as=1.98p ps=7.2u w=6.6u l=0.6u
X435 zpm bpb znm avdd pfet_06v0 ad=1.98p pd=7.2u as=1.98p ps=7.2u w=6.6u l=0.6u
X436 a_1884_1512# bna a_1860_1512# avss nfet_06v0 ad=1.98p pd=7.2u as=1.98p ps=7.2u w=6.6u l=0.6u
X437 avss bna a_2004_1344# avss nfet_06v0 ad=1.98p pd=7.2u as=1.98p ps=7.2u w=6.6u l=0.6u
X438 bpb bpb bpa_ avdd pfet_06v0 ad=1.98p pd=7.2u as=1.98p ps=7.2u w=6.6u l=0.6u
X439 zpp a_n840_1339# a_2916_1344# avss nfet_06v0 ad=1.98p pd=7.2u as=1.98p ps=7.2u w=6.6u l=0.6u
X440 a_444_1344# bna a_420_1344# avss nfet_06v0 ad=1.98p pd=7.2u as=1.98p ps=7.2u w=6.6u l=0.6u
X441 bna_ a_n840_1339# a_n780_1344# avss nfet_06v0 ad=1.98p pd=7.2u as=1.98p ps=7.2u w=6.6u l=0.6u
X442 a_3492_1512# znp a_3468_1512# avss nfet_06v0 ad=1.98p pd=7.2u as=1.98p ps=7.2u w=6.6u l=0.6u
X443 a_468_1512# bna a_444_1512# avss nfet_06v0 ad=1.98p pd=7.2u as=1.98p ps=7.2u w=6.6u l=0.6u
X444 a_1692_2052# zpp a_1668_2052# avdd pfet_06v0 ad=1.98p pd=7.2u as=1.98p ps=7.2u w=6.6u l=0.6u
X445 a_4548_1344# znm avss avss nfet_06v0 ad=1.98p pd=7.2u as=1.98p ps=7.2u w=6.6u l=0.6u
X446 a_n300_1344# a_n840_1339# a_n840_1339# avss nfet_06v0 ad=1.98p pd=7.2u as=1.98p ps=7.2u w=6.6u l=0.6u
X447 a_n840_1339# a_n840_1339# a_n348_1512# avss nfet_06v0 ad=1.98p pd=7.2u as=1.98p ps=7.2u w=6.6u l=0.6u
X448 a_120_2047# a_120_2047# a_252_2052# avdd pfet_06v0 ad=1.98p pd=7.2u as=1.98p ps=7.2u w=6.6u l=0.6u
X449 a_924_1512# znp a_900_1512# avss nfet_06v0 ad=1.98p pd=7.2u as=1.98p ps=7.2u w=6.6u l=0.6u
X450 a_n1260_2052# en enb avdd pfet_06v0 ad=1.98p pd=7.2u as=1.98p ps=7.2u w=6.6u l=0.6u
X451 bpb bpb bpa_ avdd pfet_06v0 ad=1.98p pd=7.2u as=1.98p ps=7.2u w=6.6u l=0.6u
X452 a_4116_1512# znp znm avss nfet_06v0 ad=1.98p pd=7.2u as=1.98p ps=7.2u w=6.6u l=0.6u
X453 a_300_2220# a_120_2047# a_120_2047# avdd pfet_06v0 ad=1.98p pd=7.2u as=1.98p ps=7.2u w=6.6u l=0.6u
X454 bpa_ bpb bpb avdd pfet_06v0 ad=1.98p pd=7.2u as=1.98p ps=7.2u w=6.6u l=0.6u
X455 a_2316_2052# bpa a_2292_2052# avdd pfet_06v0 ad=1.98p pd=7.2u as=1.98p ps=7.2u w=6.6u l=0.6u
X456 a_4380_2052# zpp a_4356_2052# avdd pfet_06v0 ad=1.98p pd=7.2u as=1.98p ps=7.2u w=6.6u l=0.6u
X457 enb en a_n1308_2220# avdd pfet_06v0 ad=1.98p pd=7.2u as=1.98p ps=7.2u w=6.6u l=0.6u
X458 xp0 inp ynm avdd pfet_06v0 ad=1.98p pd=7.2u as=1.98p ps=7.2u w=6.6u l=0.6u
X459 a_2076_1344# znp a_2052_1344# avss nfet_06v0 ad=1.98p pd=7.2u as=1.98p ps=7.2u w=6.6u l=0.6u
X460 bpb bpb bpa_ avdd pfet_06v0 ad=1.98p pd=7.2u as=1.98p ps=7.2u w=6.6u l=0.6u
X461 ynm inp xp0 avdd pfet_06v0 ad=1.98p pd=7.2u as=1.98p ps=7.2u w=6.6u l=0.6u
X462 a_2340_2220# bpa a_2316_2220# avdd pfet_06v0 ad=1.98p pd=7.2u as=1.98p ps=7.2u w=6.6u l=0.6u
X463 a_2892_1344# a_n840_1339# a_2964_1344# avss nfet_06v0 ad=1.98p pd=7.2u as=1.98p ps=7.2u w=6.6u l=0.6u
X464 avss bna a_468_1344# avss nfet_06v0 ad=1.98p pd=7.2u as=1.98p ps=7.2u w=6.6u l=0.6u
X465 a_4836_2052# en avdd avdd pfet_06v0 ad=1.98p pd=7.2u as=1.98p ps=7.2u w=6.6u l=0.6u
X466 a_2100_1512# znp a_2076_1512# avss nfet_06v0 ad=1.98p pd=7.2u as=1.98p ps=7.2u w=6.6u l=0.6u
X467 bpa_ bpb bpb avdd pfet_06v0 ad=1.98p pd=7.2u as=1.98p ps=7.2u w=6.6u l=0.6u
X468 zpm en a_4836_2220# avdd pfet_06v0 ad=1.98p pd=7.2u as=1.98p ps=7.2u w=6.6u l=0.6u
X469 a_4596_1344# znm o avss nfet_06v0 ad=1.98p pd=7.2u as=1.98p ps=7.2u w=6.6u l=0.6u
X470 a_2532_1344# znp ynp avss nfet_06v0 ad=1.98p pd=7.2u as=1.98p ps=7.2u w=6.6u l=0.6u
X471 bna_ a_n840_1339# a_n396_1512# avss nfet_06v0 ad=1.98p pd=7.2u as=1.98p ps=7.2u w=6.6u l=0.6u
X472 a_2556_1512# znp a_2532_1512# avss nfet_06v0 ad=1.98p pd=7.2u as=1.98p ps=7.2u w=6.6u l=0.6u
X473 a_972_1512# znp a_948_1512# avss nfet_06v0 ad=1.98p pd=7.2u as=1.98p ps=7.2u w=6.6u l=0.6u
X474 a_4164_1512# znp ynm avss nfet_06v0 ad=1.98p pd=7.2u as=1.98p ps=7.2u w=6.6u l=0.6u
X475 bpa_ bpb bpb avdd pfet_06v0 ad=1.98p pd=7.2u as=1.98p ps=7.2u w=6.6u l=0.6u
X476 avdd bpa a_2340_2052# avdd pfet_06v0 ad=1.98p pd=7.2u as=1.98p ps=7.2u w=6.6u l=0.6u
X477 a_804_2220# bpa xp0 avdd pfet_06v0 ad=1.98p pd=7.2u as=1.98p ps=7.2u w=6.6u l=0.6u
X478 a_2388_2220# bpa avdd avdd pfet_06v0 ad=1.98p pd=7.2u as=1.98p ps=7.2u w=6.6u l=0.6u
X479 a_12_1512# bna a_n12_1512# avss nfet_06v0 ad=1.98p pd=7.2u as=1.98p ps=7.2u w=6.6u l=0.6u
X480 a_4884_2052# en zpm avdd pfet_06v0 ad=1.98p pd=7.2u as=1.98p ps=7.2u w=6.6u l=0.6u
X481 bpa_ bpb bpb avdd pfet_06v0 ad=1.98p pd=7.2u as=1.98p ps=7.2u w=6.6u l=0.6u
X482 ypp zpp zpp avdd pfet_06v0 ad=1.98p pd=7.2u as=1.98p ps=7.2u w=6.6u l=0.6u
X483 avdd en a_4884_2220# avdd pfet_06v0 ad=3.96p pd=14.4u as=1.98p ps=7.2u w=6.6u l=0.6u
X484 a_1140_1344# znp a_1116_1344# avss nfet_06v0 ad=1.98p pd=7.2u as=1.98p ps=7.2u w=6.6u l=0.6u
X485 a_2604_1512# znp a_2580_1512# avss nfet_06v0 ad=1.98p pd=7.2u as=1.98p ps=7.2u w=6.6u l=0.6u
X486 o zpm avdd avdd pfet_06v0 ad=1.98p pd=7.2u as=1.98p ps=7.2u w=6.6u l=0.6u
X487 ynm znp a_3636_1344# avss nfet_06v0 ad=1.98p pd=7.2u as=1.98p ps=7.2u w=6.6u l=0.6u
X488 avss m3_4968_1416# rm3 r_width=0.6u r_length=1.8u
X489 a_1620_1512# inp ypm avss nfet_06v0 ad=1.98p pd=7.2u as=1.98p ps=7.2u w=6.6u l=0.6u
X490 a_36_1512# bna a_12_1512# avss nfet_06v0 ad=1.98p pd=7.2u as=1.98p ps=7.2u w=6.6u l=0.6u
X491 a_3228_1512# bna a_3204_1512# avss nfet_06v0 ad=1.98p pd=7.2u as=1.98p ps=7.2u w=6.6u l=0.6u
X492 a_1428_2052# zpp a_1404_2052# avdd pfet_06v0 ad=1.98p pd=7.2u as=1.98p ps=7.2u w=6.6u l=0.6u
X493 ypp zpp zpp avdd pfet_06v0 ad=1.98p pd=7.2u as=1.98p ps=7.2u w=6.6u l=0.6u
X494 a_1188_1344# znp a_1164_1344# avss nfet_06v0 ad=1.98p pd=7.2u as=1.98p ps=7.2u w=6.6u l=0.6u
X495 avdd zpp a_3012_2052# avdd pfet_06v0 ad=1.98p pd=7.2u as=1.98p ps=7.2u w=6.6u l=0.6u
X496 a_3060_2220# zpp avdd avdd pfet_06v0 ad=1.98p pd=7.2u as=1.98p ps=7.2u w=6.6u l=0.6u
X497 bpa_ bpb bpb avdd pfet_06v0 ad=1.98p pd=7.2u as=1.98p ps=7.2u w=6.6u l=0.6u
X498 a_3948_2052# zpp a_3924_2052# avdd pfet_06v0 ad=1.98p pd=7.2u as=1.98p ps=7.2u w=6.6u l=0.6u
X499 a_n996_2052# bpa a_n1020_2052# avdd pfet_06v0 ad=1.98p pd=7.2u as=1.98p ps=7.2u w=6.6u l=0.6u
X500 znm znp a_3684_1344# avss nfet_06v0 ad=1.98p pd=7.2u as=1.98p ps=7.2u w=6.6u l=0.6u
X501 xn inp a_1620_1344# avss nfet_06v0 ad=1.98p pd=7.2u as=1.98p ps=7.2u w=6.6u l=0.6u
X502 a_1668_1512# inp xn avss nfet_06v0 ad=1.98p pd=7.2u as=1.98p ps=7.2u w=6.6u l=0.6u
X503 a_3252_1344# bna a_3228_1344# avss nfet_06v0 ad=1.98p pd=7.2u as=1.98p ps=7.2u w=6.6u l=0.6u
X504 ypm zpp zpm avdd pfet_06v0 ad=1.98p pd=7.2u as=1.98p ps=7.2u w=6.6u l=0.6u
X505 a_228_1344# bna a_204_1344# avss nfet_06v0 ad=1.98p pd=7.2u as=1.98p ps=7.2u w=6.6u l=0.6u
X506 a_84_1512# bna a_60_1512# avss nfet_06v0 ad=1.98p pd=7.2u as=1.98p ps=7.2u w=6.6u l=0.6u
X507 a_1212_1512# znp a_1188_1512# avss nfet_06v0 ad=1.98p pd=7.2u as=1.98p ps=7.2u w=6.6u l=0.6u
X508 a_n1212_1344# enb avss avss nfet_06v0 ad=1.98p pd=7.2u as=1.98p ps=7.2u w=6.6u l=0.6u
X509 a_3276_1512# bna a_3252_1512# avss nfet_06v0 ad=1.98p pd=7.2u as=1.98p ps=7.2u w=6.6u l=0.6u
X510 a_1476_2052# zpp avdd avdd pfet_06v0 ad=1.98p pd=7.2u as=1.98p ps=7.2u w=6.6u l=0.6u
X511 avss en a_n1260_1512# avss nfet_06v0 ad=1.98p pd=7.2u as=1.98p ps=7.2u w=6.6u l=0.6u
X512 a_n108_1512# a_n840_1339# a_n840_1339# avss nfet_06v0 ad=1.98p pd=7.2u as=1.98p ps=7.2u w=6.6u l=0.6u
X513 a_3732_1512# a_n840_1339# znm avss nfet_06v0 ad=1.98p pd=7.2u as=1.98p ps=7.2u w=6.6u l=0.6u
X514 a_1500_2220# zpp a_1476_2220# avdd pfet_06v0 ad=1.98p pd=7.2u as=1.98p ps=7.2u w=6.6u l=0.6u
X515 a_3084_2052# zpp a_3060_2052# avdd pfet_06v0 ad=1.98p pd=7.2u as=1.98p ps=7.2u w=6.6u l=0.6u
X516 ynm inp xp1 avdd pfet_06v0 ad=1.98p pd=7.2u as=1.98p ps=7.2u w=6.6u l=0.6u
X517 a_3108_2220# zpp a_3084_2220# avdd pfet_06v0 ad=1.98p pd=7.2u as=1.98p ps=7.2u w=6.6u l=0.6u
X518 bpa_ bpb bpb avdd pfet_06v0 ad=1.98p pd=7.2u as=1.98p ps=7.2u w=6.6u l=0.6u
X519 ypp zpp a_1908_2052# avdd pfet_06v0 ad=1.98p pd=7.2u as=1.98p ps=7.2u w=6.6u l=0.6u
X520 ypm zpp a_3972_2052# avdd pfet_06v0 ad=1.98p pd=7.2u as=1.98p ps=7.2u w=6.6u l=0.6u
X521 a_1956_2220# zpp ypp avdd pfet_06v0 ad=1.98p pd=7.2u as=1.98p ps=7.2u w=6.6u l=0.6u
X522 avdd en a_n1068_2052# avdd pfet_06v0 ad=1.98p pd=7.2u as=1.98p ps=7.2u w=6.6u l=0.6u
X523 ypm inp a_1668_1344# avss nfet_06v0 ad=1.98p pd=7.2u as=1.98p ps=7.2u w=6.6u l=0.6u
X524 a_n1068_2220# en bpa avdd pfet_06v0 ad=1.98p pd=7.2u as=1.98p ps=7.2u w=6.6u l=0.6u
X525 a_516_2052# bpa avdd avdd pfet_06v0 ad=1.98p pd=7.2u as=1.98p ps=7.2u w=6.6u l=0.6u
X526 a_540_2220# bpa a_516_2220# avdd pfet_06v0 ad=1.98p pd=7.2u as=1.98p ps=7.2u w=6.6u l=0.6u
X527 znm bpb zpm avdd pfet_06v0 ad=1.98p pd=7.2u as=1.98p ps=7.2u w=6.6u l=0.6u
X528 bpb bpb bpa_ avdd pfet_06v0 ad=1.98p pd=7.2u as=1.98p ps=7.2u w=6.6u l=0.6u
X529 a_276_1344# bna a_252_1344# avss nfet_06v0 ad=1.98p pd=7.2u as=1.98p ps=7.2u w=6.6u l=0.6u
X530 avdd zpm o avdd pfet_06v0 ad=1.98p pd=7.2u as=1.98p ps=7.2u w=6.6u l=0.6u
X531 bpb bna a_276_1512# avss nfet_06v0 ad=1.98p pd=7.2u as=1.98p ps=7.2u w=6.6u l=0.6u
X532 a_n588_1344# a_n840_1339# a_n840_1339# avss nfet_06v0 ad=1.98p pd=7.2u as=1.98p ps=7.2u w=6.6u l=0.6u
X533 a_n1260_1344# en enb avss nfet_06v0 ad=1.98p pd=7.2u as=1.98p ps=7.2u w=6.6u l=0.6u
X534 a_n396_2220# bpa a_n420_2220# avdd pfet_06v0 ad=1.98p pd=7.2u as=1.98p ps=7.2u w=6.6u l=0.6u
X535 a_4380_1344# znp a_4356_1344# avss nfet_06v0 ad=1.98p pd=7.2u as=1.98p ps=7.2u w=6.6u l=0.6u
X536 ynp znp a_2292_1344# avss nfet_06v0 ad=1.98p pd=7.2u as=1.98p ps=7.2u w=6.6u l=0.6u
X537 a_n840_1339# a_n840_1339# a_n156_1344# avss nfet_06v0 ad=1.98p pd=7.2u as=1.98p ps=7.2u w=6.6u l=0.6u
X538 enb en a_n1308_1512# avss nfet_06v0 ad=1.98p pd=7.2u as=1.98p ps=7.2u w=6.6u l=0.6u
X539 a_n156_1512# a_n840_1339# bna_ avss nfet_06v0 ad=1.98p pd=7.2u as=1.98p ps=7.2u w=6.6u l=0.6u
X540 a_732_1344# znp a_708_1344# avss nfet_06v0 ad=1.98p pd=7.2u as=1.98p ps=7.2u w=6.6u l=0.6u
X541 a_756_1512# znp a_732_1512# avss nfet_06v0 ad=1.98p pd=7.2u as=1.98p ps=7.2u w=6.6u l=0.6u
X542 a_2340_1512# znp ynp avss nfet_06v0 ad=1.98p pd=7.2u as=1.98p ps=7.2u w=6.6u l=0.6u
X543 ynp inm xp1 avdd pfet_06v0 ad=1.98p pd=7.2u as=1.98p ps=7.2u w=6.6u l=0.6u
X544 a_4836_1344# enb avss avss nfet_06v0 ad=1.98p pd=7.2u as=1.98p ps=7.2u w=6.6u l=0.6u
X545 a_2004_2220# zpp a_1980_2220# avdd pfet_06v0 ad=1.98p pd=7.2u as=1.98p ps=7.2u w=6.6u l=0.6u
X546 a_n840_1339# a_n840_1339# a_n636_1512# avss nfet_06v0 ad=1.98p pd=7.2u as=1.98p ps=7.2u w=6.6u l=0.6u
X547 znm enb a_4836_1512# avss nfet_06v0 ad=1.98p pd=7.2u as=1.98p ps=7.2u w=6.6u l=0.6u
X548 a_564_2052# bpa a_540_2052# avdd pfet_06v0 ad=1.98p pd=7.2u as=1.98p ps=7.2u w=6.6u l=0.6u
X549 znp bpb a_2124_2052# avdd pfet_06v0 ad=1.98p pd=7.2u as=1.98p ps=7.2u w=6.6u l=0.6u
X550 xp0 bpa a_564_2220# avdd pfet_06v0 ad=1.98p pd=7.2u as=1.98p ps=7.2u w=6.6u l=0.6u
X551 bpb bpb bpa_ avdd pfet_06v0 ad=1.98p pd=7.2u as=1.98p ps=7.2u w=6.6u l=0.6u
X552 a_n420_2052# bpa a_n444_2052# avdd pfet_06v0 ad=1.98p pd=7.2u as=1.98p ps=7.2u w=6.6u l=0.6u
X553 avdd zpm o avdd pfet_06v0 ad=1.98p pd=7.2u as=1.98p ps=7.2u w=6.6u l=0.6u
X554 a_n444_2220# bpa avdd avdd pfet_06v0 ad=1.98p pd=7.2u as=1.98p ps=7.2u w=6.6u l=0.6u
X555 a_120_2047# a_120_2047# avdd avdd pfet_06v0 ad=1.98p pd=7.2u as=1.98p ps=7.2u w=6.6u l=0.6u
X556 znp znp a_2340_1344# avss nfet_06v0 ad=1.98p pd=7.2u as=1.98p ps=7.2u w=6.6u l=0.6u
X557 bna_ a_n840_1339# a_n204_1344# avss nfet_06v0 ad=1.98p pd=7.2u as=1.98p ps=7.2u w=6.6u l=0.6u
X558 a_2628_2220# bpa a_2556_2052# avdd pfet_06v0 ad=1.98p pd=7.2u as=1.98p ps=7.2u w=6.6u l=0.6u
X559 zpm bpb znm avdd pfet_06v0 ad=1.98p pd=7.2u as=1.98p ps=7.2u w=6.6u l=0.6u
X560 znm bpb zpm avdd pfet_06v0 ad=1.98p pd=7.2u as=1.98p ps=7.2u w=6.6u l=0.6u
X561 a_804_1512# znp a_780_1512# avss nfet_06v0 ad=1.98p pd=7.2u as=1.98p ps=7.2u w=6.6u l=0.6u
X562 a_2388_1512# znp znp avss nfet_06v0 ad=1.98p pd=7.2u as=1.98p ps=7.2u w=6.6u l=0.6u
X563 bpa_ bpb bpb avdd pfet_06v0 ad=1.98p pd=7.2u as=1.98p ps=7.2u w=6.6u l=0.6u
X564 a_4884_1344# enb znm avss nfet_06v0 ad=1.98p pd=7.2u as=1.98p ps=7.2u w=6.6u l=0.6u
X565 bna_ a_n840_1339# a_n684_1512# avss nfet_06v0 ad=1.98p pd=7.2u as=1.98p ps=7.2u w=6.6u l=0.6u
X566 avss enb a_4884_1512# avss nfet_06v0 ad=3.96p pd=14.4u as=1.98p ps=7.2u w=6.6u l=0.6u
X567 a_2844_1512# bna a_2820_1512# avss nfet_06v0 ad=1.98p pd=7.2u as=1.98p ps=7.2u w=6.6u l=0.6u
X568 znp bpb a_2124_2052# avdd pfet_06v0 ad=1.98p pd=7.2u as=1.98p ps=7.2u w=6.6u l=0.6u
X569 a_4452_1512# znm avss avss nfet_06v0 ad=1.98p pd=7.2u as=1.98p ps=7.2u w=6.6u l=0.6u
X570 a_2652_2052# bpa a_2628_2052# avdd pfet_06v0 ad=1.98p pd=7.2u as=1.98p ps=7.2u w=6.6u l=0.6u
X571 a_2676_2220# bpa a_2652_2220# avdd pfet_06v0 ad=1.98p pd=7.2u as=1.98p ps=7.2u w=6.6u l=0.6u
X572 ypm zpp zpm avdd pfet_06v0 ad=1.98p pd=7.2u as=1.98p ps=7.2u w=6.6u l=0.6u
X573 a_1428_1344# bna a_1404_1344# avss nfet_06v0 ad=1.98p pd=7.2u as=1.98p ps=7.2u w=6.6u l=0.6u
X574 zpp a_n840_1339# a_3012_1344# avss nfet_06v0 ad=1.98p pd=7.2u as=1.98p ps=7.2u w=6.6u l=0.6u
X575 a_2892_1344# bna a_2868_1512# avss nfet_06v0 ad=1.98p pd=7.2u as=1.98p ps=7.2u w=6.6u l=0.6u
X576 zpm a_n840_1339# a_3924_1344# avss nfet_06v0 ad=1.98p pd=7.2u as=1.98p ps=7.2u w=6.6u l=0.6u
X577 a_n36_1344# bna a_n60_1344# avss nfet_06v0 ad=1.98p pd=7.2u as=1.98p ps=7.2u w=6.6u l=0.6u
X578 a_n996_1344# bna a_n1020_1344# avss nfet_06v0 ad=1.98p pd=7.2u as=1.98p ps=7.2u w=6.6u l=0.6u
X579 a_3060_1512# a_n840_1339# zpp avss nfet_06v0 ad=1.98p pd=7.2u as=1.98p ps=7.2u w=6.6u l=0.6u
X580 avdd bpa a_1236_2052# avdd pfet_06v0 ad=1.98p pd=7.2u as=1.98p ps=7.2u w=6.6u l=0.6u
X581 a_3516_1512# znp a_3492_1512# avss nfet_06v0 ad=1.98p pd=7.2u as=1.98p ps=7.2u w=6.6u l=0.6u
X582 a_1716_2052# zpp a_1692_2052# avdd pfet_06v0 ad=1.98p pd=7.2u as=1.98p ps=7.2u w=6.6u l=0.6u
X583 zpm zpp ypm avdd pfet_06v0 ad=1.98p pd=7.2u as=1.98p ps=7.2u w=6.6u l=0.6u
X584 a_1476_1344# inm xn avss nfet_06v0 ad=1.98p pd=7.2u as=1.98p ps=7.2u w=6.6u l=0.6u
X585 ypm zpp a_1716_2220# avdd pfet_06v0 ad=1.98p pd=7.2u as=1.98p ps=7.2u w=6.6u l=0.6u
X586 a_3324_2052# zpp a_3300_2052# avdd pfet_06v0 ad=1.98p pd=7.2u as=1.98p ps=7.2u w=6.6u l=0.6u
X587 a_3348_2220# zpp a_3324_2220# avdd pfet_06v0 ad=1.98p pd=7.2u as=1.98p ps=7.2u w=6.6u l=0.6u
X588 ypp inm a_1476_1512# avss nfet_06v0 ad=1.98p pd=7.2u as=1.98p ps=7.2u w=6.6u l=0.6u
X589 a_2892_1344# a_n840_1339# a_3060_1344# avss nfet_06v0 ad=1.98p pd=7.2u as=1.98p ps=7.2u w=6.6u l=0.6u
X590 a_1044_1512# znp a_1020_1512# avss nfet_06v0 ad=1.98p pd=7.2u as=1.98p ps=7.2u w=6.6u l=0.6u
X591 znm a_n840_1339# a_3972_1344# avss nfet_06v0 ad=1.98p pd=7.2u as=1.98p ps=7.2u w=6.6u l=0.6u
X592 a_1932_1344# bna a_1908_1344# avss nfet_06v0 ad=1.98p pd=7.2u as=1.98p ps=7.2u w=6.6u l=0.6u
X593 bna_ a_n840_1339# a_n108_1344# avss nfet_06v0 ad=1.98p pd=7.2u as=1.98p ps=7.2u w=6.6u l=0.6u
X594 avss enb a_n1068_1344# avss nfet_06v0 ad=1.98p pd=7.2u as=1.98p ps=7.2u w=6.6u l=0.6u
X595 a_3108_1512# a_n840_1339# a_2892_1344# avss nfet_06v0 ad=1.98p pd=7.2u as=1.98p ps=7.2u w=6.6u l=0.6u
X596 a_n1308_2220# en avdd avdd pfet_06v0 ad=1.98p pd=7.2u as=3.96p ps=14.4u w=6.6u l=0.6u
X597 a_1956_1512# bna a_1932_1512# avss nfet_06v0 ad=1.98p pd=7.2u as=1.98p ps=7.2u w=6.6u l=0.6u
X598 a_1308_2052# zpp a_1284_2052# avdd pfet_06v0 ad=1.98p pd=7.2u as=1.98p ps=7.2u w=6.6u l=0.6u
X599 a_n1068_1512# enb bna avss nfet_06v0 ad=1.98p pd=7.2u as=1.98p ps=7.2u w=6.6u l=0.6u
X600 a_516_1344# znp avss avss nfet_06v0 ad=1.98p pd=7.2u as=1.98p ps=7.2u w=6.6u l=0.6u
X601 a_n828_1344# a_n840_1339# bna_ avss nfet_06v0 ad=1.98p pd=7.2u as=1.98p ps=7.2u w=6.6u l=0.6u
X602 a_540_1512# znp a_516_1512# avss nfet_06v0 ad=1.98p pd=7.2u as=1.98p ps=7.2u w=6.6u l=0.6u
X603 ynm znp a_3540_1512# avss nfet_06v0 ad=1.98p pd=7.2u as=1.98p ps=7.2u w=6.6u l=0.6u
X604 a_1764_2052# zpp ypm avdd pfet_06v0 ad=1.98p pd=7.2u as=1.98p ps=7.2u w=6.6u l=0.6u
X605 avss znm a_4596_1344# avss nfet_06v0 ad=1.98p pd=7.2u as=1.98p ps=7.2u w=6.6u l=0.6u
X606 a_n396_1512# a_n840_1339# a_n840_1339# avss nfet_06v0 ad=1.98p pd=7.2u as=1.98p ps=7.2u w=6.6u l=0.6u
X607 a_1788_2220# zpp a_1764_2220# avdd pfet_06v0 ad=1.98p pd=7.2u as=1.98p ps=7.2u w=6.6u l=0.6u
X608 a_348_2052# a_120_2047# a_120_2047# avdd pfet_06v0 ad=1.98p pd=7.2u as=1.98p ps=7.2u w=6.6u l=0.6u
X609 avdd zpp a_3348_2052# avdd pfet_06v0 ad=1.98p pd=7.2u as=1.98p ps=7.2u w=6.6u l=0.6u
X610 a_1332_2220# zpp a_1308_2220# avdd pfet_06v0 ad=1.98p pd=7.2u as=1.98p ps=7.2u w=6.6u l=0.6u
X611 a_3396_2220# zpp avdd avdd pfet_06v0 ad=1.98p pd=7.2u as=1.98p ps=7.2u w=6.6u l=0.6u
X612 bpb bpb bpa_ avdd pfet_06v0 ad=1.98p pd=7.2u as=1.98p ps=7.2u w=6.6u l=0.6u
X613 a_1092_1512# znp ynm avss nfet_06v0 ad=1.98p pd=7.2u as=1.98p ps=7.2u w=6.6u l=0.6u
X614 a_2004_1512# bna a_1980_1512# avss nfet_06v0 ad=1.98p pd=7.2u as=1.98p ps=7.2u w=6.6u l=0.6u
X615 a_2148_1344# znp a_2124_1344# avss nfet_06v0 ad=1.98p pd=7.2u as=1.98p ps=7.2u w=6.6u l=0.6u
X616 bpa_ bpb bpb avdd pfet_06v0 ad=1.98p pd=7.2u as=1.98p ps=7.2u w=6.6u l=0.6u
X617 a_828_2220# bpa a_804_2220# avdd pfet_06v0 ad=1.98p pd=7.2u as=1.98p ps=7.2u w=6.6u l=0.6u
X618 a_3852_2220# zpp a_3828_2220# avdd pfet_06v0 ad=1.98p pd=7.2u as=1.98p ps=7.2u w=6.6u l=0.6u
X619 a_564_1344# znp a_540_1344# avss nfet_06v0 ad=1.98p pd=7.2u as=1.98p ps=7.2u w=6.6u l=0.6u
X620 zpm zpp ypm avdd pfet_06v0 ad=1.98p pd=7.2u as=1.98p ps=7.2u w=6.6u l=0.6u
X621 a_588_1512# znp a_564_1512# avss nfet_06v0 ad=1.98p pd=7.2u as=1.98p ps=7.2u w=6.6u l=0.6u
X622 a_n876_1344# bna a_n900_1344# avss nfet_06v0 ad=1.98p pd=7.2u as=1.98p ps=7.2u w=6.6u l=0.6u
X623 o znm a_4644_1344# avss nfet_06v0 ad=1.98p pd=7.2u as=1.98p ps=7.2u w=6.6u l=0.6u
X624 a_n840_1339# a_n840_1339# a_n444_1344# avss nfet_06v0 ad=1.98p pd=7.2u as=1.98p ps=7.2u w=6.6u l=0.6u
X625 a_n444_1512# a_n840_1339# bna_ avss nfet_06v0 ad=1.98p pd=7.2u as=1.98p ps=7.2u w=6.6u l=0.6u
X626 a_132_1512# bna avss avss nfet_06v0 ad=1.98p pd=7.2u as=1.98p ps=7.2u w=6.6u l=0.6u
X627 a_4212_1344# znp znm avss nfet_06v0 ad=1.98p pd=7.2u as=1.98p ps=7.2u w=6.6u l=0.6u
X628 a_2628_1512# znp a_2604_1512# avss nfet_06v0 ad=1.98p pd=7.2u as=1.98p ps=7.2u w=6.6u l=0.6u
X629 a_396_2052# a_120_2047# a_120_2047# avdd pfet_06v0 ad=1.98p pd=7.2u as=1.98p ps=7.2u w=6.6u l=0.6u
X630 ynm znp a_4212_1512# avss nfet_06v0 ad=1.98p pd=7.2u as=1.98p ps=7.2u w=6.6u l=0.6u
X631 bpb bpb bpa_ avdd pfet_06v0 ad=1.98p pd=7.2u as=1.98p ps=7.2u w=6.6u l=0.6u
X632 o zpm avdd avdd pfet_06v0 ad=1.98p pd=7.2u as=1.98p ps=7.2u w=6.6u l=0.6u
X633 a_n900_1512# bna a_n924_1512# avss nfet_06v0 ad=1.98p pd=7.2u as=1.98p ps=7.2u w=6.6u l=0.6u
X634 a_852_2052# bpa a_828_2052# avdd pfet_06v0 ad=1.98p pd=7.2u as=1.98p ps=7.2u w=6.6u l=0.6u
X635 a_2436_2052# bpa a_2412_2052# avdd pfet_06v0 ad=1.98p pd=7.2u as=1.98p ps=7.2u w=6.6u l=0.6u
X636 bpa_ bpb bpb avdd pfet_06v0 ad=1.98p pd=7.2u as=1.98p ps=7.2u w=6.6u l=0.6u
X637 avdd bpa a_852_2220# avdd pfet_06v0 ad=1.98p pd=7.2u as=1.98p ps=7.2u w=6.6u l=0.6u
X638 a_2460_2052# bpa a_2436_2220# avdd pfet_06v0 ad=1.98p pd=7.2u as=1.98p ps=7.2u w=6.6u l=0.6u
X639 ypm zpp zpm avdd pfet_06v0 ad=1.98p pd=7.2u as=1.98p ps=7.2u w=6.6u l=0.6u
X640 a_2196_1344# znp a_2172_1344# avss nfet_06v0 ad=1.98p pd=7.2u as=1.98p ps=7.2u w=6.6u l=0.6u
X641 zpm zpp ypm avdd pfet_06v0 ad=1.98p pd=7.2u as=1.98p ps=7.2u w=6.6u l=0.6u
X642 bpb bpb bpa_ avdd pfet_06v0 ad=1.98p pd=7.2u as=1.98p ps=7.2u w=6.6u l=0.6u
X643 a_2652_1344# znp a_2628_1344# avss nfet_06v0 ad=1.98p pd=7.2u as=1.98p ps=7.2u w=6.6u l=0.6u
X644 zpp zpp ypp avdd pfet_06v0 ad=1.98p pd=7.2u as=1.98p ps=7.2u w=6.6u l=0.6u
X645 a_2676_1512# znp a_2652_1512# avss nfet_06v0 ad=1.98p pd=7.2u as=1.98p ps=7.2u w=6.6u l=0.6u
X646 avdd zpm o avdd pfet_06v0 ad=1.98p pd=7.2u as=1.98p ps=7.2u w=6.6u l=0.6u
X647 a_4284_1512# znp a_4260_1512# avss nfet_06v0 ad=1.98p pd=7.2u as=1.98p ps=7.2u w=6.6u l=0.6u
X648 znp bpb a_2460_2052# avdd pfet_06v0 ad=1.98p pd=7.2u as=1.98p ps=7.2u w=6.6u l=0.6u
X649 a_2460_2052# bpb znp avdd pfet_06v0 ad=1.98p pd=7.2u as=1.98p ps=7.2u w=6.6u l=0.6u
X650 znm bpb zpm avdd pfet_06v0 ad=1.98p pd=7.2u as=1.98p ps=7.2u w=6.6u l=0.6u
X651 a_2052_2220# bpa avdd avdd pfet_06v0 ad=1.98p pd=7.2u as=1.98p ps=7.2u w=6.6u l=0.6u
X652 bpb bpb bpa_ avdd pfet_06v0 ad=1.98p pd=7.2u as=1.98p ps=7.2u w=6.6u l=0.6u
X653 avss znp a_1236_1344# avss nfet_06v0 ad=1.98p pd=7.2u as=1.98p ps=7.2u w=6.6u l=0.6u
X654 a_2964_2220# zpp ypp avdd pfet_06v0 ad=1.98p pd=7.2u as=1.98p ps=7.2u w=6.6u l=0.6u
X655 avdd zpm o avdd pfet_06v0 ad=1.98p pd=7.2u as=1.98p ps=7.2u w=6.6u l=0.6u
X656 a_3780_1344# a_n840_1339# zpm avss nfet_06v0 ad=1.98p pd=7.2u as=1.98p ps=7.2u w=6.6u l=0.6u
X657 a_1716_1344# inp ypm avss nfet_06v0 ad=1.98p pd=7.2u as=1.98p ps=7.2u w=6.6u l=0.6u
X658 xn inp a_1716_1512# avss nfet_06v0 ad=1.98p pd=7.2u as=1.98p ps=7.2u w=6.6u l=0.6u
X659 a_3324_1344# bna a_3300_1344# avss nfet_06v0 ad=1.98p pd=7.2u as=1.98p ps=7.2u w=6.6u l=0.6u
X660 a_3348_1512# bna a_3324_1512# avss nfet_06v0 ad=1.98p pd=7.2u as=1.98p ps=7.2u w=6.6u l=0.6u
X661 ypm zpp a_1524_2052# avdd pfet_06v0 ad=1.98p pd=7.2u as=1.98p ps=7.2u w=6.6u l=0.6u
X662 a_n1308_1512# en avss avss nfet_06v0 ad=1.98p pd=7.2u as=3.96p ps=14.4u w=6.6u l=0.6u
X663 a_1308_1344# bna a_1284_1344# avss nfet_06v0 ad=1.98p pd=7.2u as=1.98p ps=7.2u w=6.6u l=0.6u
X664 zpp zpp ypp avdd pfet_06v0 ad=1.98p pd=7.2u as=1.98p ps=7.2u w=6.6u l=0.6u
X665 xp1 inm ynp avdd pfet_06v0 ad=1.98p pd=7.2u as=1.98p ps=7.2u w=6.6u l=0.6u
X666 ypp zpp zpp avdd pfet_06v0 ad=1.98p pd=7.2u as=1.98p ps=7.2u w=6.6u l=0.6u
X667 a_n1116_2052# enb bpa_ avdd pfet_06v0 ad=1.98p pd=7.2u as=1.98p ps=7.2u w=6.6u l=0.6u
X668 a_1764_1344# inm xn avss nfet_06v0 ad=1.98p pd=7.2u as=1.98p ps=7.2u w=6.6u l=0.6u
X669 znm bpb zpm avdd pfet_06v0 ad=1.98p pd=7.2u as=1.98p ps=7.2u w=6.6u l=0.6u
X670 ypp inm a_1764_1512# avss nfet_06v0 ad=1.98p pd=7.2u as=1.98p ps=7.2u w=6.6u l=0.6u
X671 avss bna a_3348_1344# avss nfet_06v0 ad=1.98p pd=7.2u as=1.98p ps=7.2u w=6.6u l=0.6u
X672 zpm bpb znm avdd pfet_06v0 ad=1.98p pd=7.2u as=1.98p ps=7.2u w=6.6u l=0.6u
X673 a_348_1344# bna a_324_1344# avss nfet_06v0 ad=1.98p pd=7.2u as=1.98p ps=7.2u w=6.6u l=0.6u
X674 a_1332_1512# bna a_1308_1512# avss nfet_06v0 ad=1.98p pd=7.2u as=1.98p ps=7.2u w=6.6u l=0.6u
X675 a_3396_1512# znp avss avss nfet_06v0 ad=1.98p pd=7.2u as=1.98p ps=7.2u w=6.6u l=0.6u
X676 a_n204_1344# a_n840_1339# a_n840_1339# avss nfet_06v0 ad=1.98p pd=7.2u as=1.98p ps=7.2u w=6.6u l=0.6u
X677 a_1596_2052# zpp a_1572_2052# avdd pfet_06v0 ad=1.98p pd=7.2u as=1.98p ps=7.2u w=6.6u l=0.6u
X678 zpm a_n840_1339# a_3828_1512# avss nfet_06v0 ad=1.98p pd=7.2u as=1.98p ps=7.2u w=6.6u l=0.6u
X679 zpp zpp ypp avdd pfet_06v0 ad=1.98p pd=7.2u as=1.98p ps=7.2u w=6.6u l=0.6u
X680 a_n840_1339# a_n840_1339# a_n252_1512# avss nfet_06v0 ad=1.98p pd=7.2u as=1.98p ps=7.2u w=6.6u l=0.6u
X681 a_828_1512# znp a_804_1512# avss nfet_06v0 ad=1.98p pd=7.2u as=1.98p ps=7.2u w=6.6u l=0.6u
X682 xp1 inm ynp avdd pfet_06v0 ad=1.98p pd=7.2u as=1.98p ps=7.2u w=6.6u l=0.6u
X683 a_120_2047# a_120_2047# a_156_2052# avdd pfet_06v0 ad=1.98p pd=7.2u as=1.98p ps=7.2u w=6.6u l=0.6u
X684 a_4020_1512# a_n840_1339# znm avss nfet_06v0 ad=1.98p pd=7.2u as=1.98p ps=7.2u w=6.6u l=0.6u
X685 a_n1164_2052# enb bpa avdd pfet_06v0 ad=1.98p pd=7.2u as=1.98p ps=7.2u w=6.6u l=0.6u
X686 bpa en a_n1212_2220# avdd pfet_06v0 ad=1.98p pd=7.2u as=1.98p ps=7.2u w=6.6u l=0.6u
X687 xp0 inm ynp avdd pfet_06v0 ad=1.98p pd=7.2u as=1.98p ps=7.2u w=6.6u l=0.6u
X688 a_2220_2052# bpb znp avdd pfet_06v0 ad=1.98p pd=7.2u as=1.98p ps=7.2u w=6.6u l=0.6u
X689 zpm bpb znm avdd pfet_06v0 ad=1.98p pd=7.2u as=1.98p ps=7.2u w=6.6u l=0.6u
X690 bpa_ bpa a_n972_2052# avdd pfet_06v0 ad=1.98p pd=7.2u as=1.98p ps=7.2u w=6.6u l=0.6u
X691 a_396_1344# bna a_372_1344# avss nfet_06v0 ad=1.98p pd=7.2u as=1.98p ps=7.2u w=6.6u l=0.6u
X692 ynp inm xp0 avdd pfet_06v0 ad=1.98p pd=7.2u as=1.98p ps=7.2u w=6.6u l=0.6u
X693 a_n492_2052# bpa a_n516_2052# avdd pfet_06v0 ad=1.98p pd=7.2u as=1.98p ps=7.2u w=6.6u l=0.6u
X694 o zpm avdd avdd pfet_06v0 ad=1.98p pd=7.2u as=1.98p ps=7.2u w=6.6u l=0.6u
X695 a_4500_1344# znm o avss nfet_06v0 ad=1.98p pd=7.2u as=1.98p ps=7.2u w=6.6u l=0.6u
X696 a_2436_1344# znp ynp avss nfet_06v0 ad=1.98p pd=7.2u as=1.98p ps=7.2u w=6.6u l=0.6u
X697 a_n252_1344# a_n840_1339# bna_ avss nfet_06v0 ad=1.98p pd=7.2u as=1.98p ps=7.2u w=6.6u l=0.6u
X698 a_n516_2220# bpa a_n540_2220# avdd pfet_06v0 ad=1.98p pd=7.2u as=1.98p ps=7.2u w=6.6u l=0.6u
X699 a_852_1344# znp a_828_1344# avss nfet_06v0 ad=1.98p pd=7.2u as=1.98p ps=7.2u w=6.6u l=0.6u
X700 bna_ a_n840_1339# a_n300_1512# avss nfet_06v0 ad=1.98p pd=7.2u as=1.98p ps=7.2u w=6.6u l=0.6u
X701 avss znp a_852_1512# avss nfet_06v0 ad=1.98p pd=7.2u as=1.98p ps=7.2u w=6.6u l=0.6u
X702 zpm a_n840_1339# a_4020_1344# avss nfet_06v0 ad=1.98p pd=7.2u as=1.98p ps=7.2u w=6.6u l=0.6u
X703 znp znp a_2436_1512# avss nfet_06v0 ad=1.98p pd=7.2u as=1.98p ps=7.2u w=6.6u l=0.6u
X704 a_4068_1512# a_n840_1339# zpm avss nfet_06v0 ad=1.98p pd=7.2u as=1.98p ps=7.2u w=6.6u l=0.6u
X705 a_n732_1512# a_n840_1339# bna_ avss nfet_06v0 ad=1.98p pd=7.2u as=1.98p ps=7.2u w=6.6u l=0.6u
X706 a_2916_1512# a_n840_1339# a_2892_1344# avss nfet_06v0 ad=1.98p pd=7.2u as=1.98p ps=7.2u w=6.6u l=0.6u
X707 xp0 inm ynp avdd pfet_06v0 ad=1.98p pd=7.2u as=1.98p ps=7.2u w=6.6u l=0.6u
X708 a_2220_2052# bpb znp avdd pfet_06v0 ad=1.98p pd=7.2u as=1.98p ps=7.2u w=6.6u l=0.6u
X709 avss znm a_4500_1512# avss nfet_06v0 ad=1.98p pd=7.2u as=1.98p ps=7.2u w=6.6u l=0.6u
X710 ynm inp xp0 avdd pfet_06v0 ad=1.98p pd=7.2u as=1.98p ps=7.2u w=6.6u l=0.6u
X711 a_n540_2052# bpa bpa_ avdd pfet_06v0 ad=1.98p pd=7.2u as=1.98p ps=7.2u w=6.6u l=0.6u
X712 a_2724_2052# zpp avdd avdd pfet_06v0 ad=1.98p pd=7.2u as=1.98p ps=7.2u w=6.6u l=0.6u
X713 o zpm avdd avdd pfet_06v0 ad=1.98p pd=7.2u as=1.98p ps=7.2u w=6.6u l=0.6u
X714 a_252_2220# a_120_2047# a_120_2047# avdd pfet_06v0 ad=1.98p pd=7.2u as=1.98p ps=7.2u w=6.6u l=0.6u
X715 a_2484_1344# znp znp avss nfet_06v0 ad=1.98p pd=7.2u as=1.98p ps=7.2u w=6.6u l=0.6u
X716 bpa_ bpb bpb avdd pfet_06v0 ad=1.98p pd=7.2u as=1.98p ps=7.2u w=6.6u l=0.6u
X717 a_2748_2220# zpp a_2724_2220# avdd pfet_06v0 ad=1.98p pd=7.2u as=1.98p ps=7.2u w=6.6u l=0.6u
X718 ypm zpp zpm avdd pfet_06v0 ad=1.98p pd=7.2u as=1.98p ps=7.2u w=6.6u l=0.6u
X719 a_4356_2220# zpp ypm avdd pfet_06v0 ad=1.98p pd=7.2u as=1.98p ps=7.2u w=6.6u l=0.6u
X720 znm a_n840_1339# a_4068_1344# avss nfet_06v0 ad=1.98p pd=7.2u as=1.98p ps=7.2u w=6.6u l=0.6u
X721 ynp znp a_2484_1512# avss nfet_06v0 ad=1.98p pd=7.2u as=1.98p ps=7.2u w=6.6u l=0.6u
X722 a_2052_1512# znp avss avss nfet_06v0 ad=1.98p pd=7.2u as=1.98p ps=7.2u w=6.6u l=0.6u
X723 a_n780_1512# a_n840_1339# a_n840_1339# avss nfet_06v0 ad=1.98p pd=7.2u as=1.98p ps=7.2u w=6.6u l=0.6u
X724 a_2964_1512# a_n840_1339# zpp avss nfet_06v0 ad=1.98p pd=7.2u as=1.98p ps=7.2u w=6.6u l=0.6u
X725 avdd zpm o avdd pfet_06v0 ad=1.98p pd=7.2u as=1.98p ps=7.2u w=6.6u l=0.6u
X726 o znm a_4548_1512# avss nfet_06v0 ad=1.98p pd=7.2u as=1.98p ps=7.2u w=6.6u l=0.6u
X727 a_2772_2052# zpp a_2748_2052# avdd pfet_06v0 ad=1.98p pd=7.2u as=1.98p ps=7.2u w=6.6u l=0.6u
X728 ypp zpp a_2772_2220# avdd pfet_06v0 ad=1.98p pd=7.2u as=1.98p ps=7.2u w=6.6u l=0.6u
X729 a_4404_2220# zpp a_4380_2220# avdd pfet_06v0 ad=1.98p pd=7.2u as=1.98p ps=7.2u w=6.6u l=0.6u
X730 xn inm a_1524_1344# avss nfet_06v0 ad=1.98p pd=7.2u as=1.98p ps=7.2u w=6.6u l=0.6u
X731 a_3420_2220# zpp a_3396_2220# avdd pfet_06v0 ad=1.98p pd=7.2u as=1.98p ps=7.2u w=6.6u l=0.6u
X732 a_3156_1344# a_n840_1339# zpp avss nfet_06v0 ad=1.98p pd=7.2u as=1.98p ps=7.2u w=6.6u l=0.6u
X733 a_1116_1512# znp a_1092_1512# avss nfet_06v0 ad=1.98p pd=7.2u as=1.98p ps=7.2u w=6.6u l=0.6u
X734 a_2892_1344# a_n840_1339# a_3156_1512# avss nfet_06v0 ad=1.98p pd=7.2u as=1.98p ps=7.2u w=6.6u l=0.6u
X735 znm znp a_3588_1344# avss nfet_06v0 ad=1.98p pd=7.2u as=1.98p ps=7.2u w=6.6u l=0.6u
X736 a_n1116_1344# en bna_ avss nfet_06v0 ad=1.98p pd=7.2u as=1.98p ps=7.2u w=6.6u l=0.6u
X737 a_1380_2052# zpp ypp avdd pfet_06v0 ad=1.98p pd=7.2u as=1.98p ps=7.2u w=6.6u l=0.6u
X738 a_3636_1512# znp znm avss nfet_06v0 ad=1.98p pd=7.2u as=1.98p ps=7.2u w=6.6u l=0.6u
X739 avdd zpp a_1812_2052# avdd pfet_06v0 ad=1.98p pd=7.2u as=1.98p ps=7.2u w=6.6u l=0.6u
X740 avdd zpp a_3876_2052# avdd pfet_06v0 ad=1.98p pd=7.2u as=1.98p ps=7.2u w=6.6u l=0.6u
X741 ypm inp a_1572_1344# avss nfet_06v0 ad=1.98p pd=7.2u as=1.98p ps=7.2u w=6.6u l=0.6u
X742 a_1860_2220# zpp avdd avdd pfet_06v0 ad=1.98p pd=7.2u as=1.98p ps=7.2u w=6.6u l=0.6u
X743 a_3444_2052# zpp a_3420_2052# avdd pfet_06v0 ad=1.98p pd=7.2u as=1.98p ps=7.2u w=6.6u l=0.6u
X744 ypm zpp a_3444_2220# avdd pfet_06v0 ad=1.98p pd=7.2u as=1.98p ps=7.2u w=6.6u l=0.6u
X745 a_120_2047# a_120_2047# a_396_2052# avdd pfet_06v0 ad=1.98p pd=7.2u as=1.98p ps=7.2u w=6.6u l=0.6u
X746 a_3204_1344# bna a_2892_1344# avss nfet_06v0 ad=1.98p pd=7.2u as=1.98p ps=7.2u w=6.6u l=0.6u
X747 a_1164_1512# znp a_1140_1512# avss nfet_06v0 ad=1.98p pd=7.2u as=1.98p ps=7.2u w=6.6u l=0.6u
X748 a_180_1344# bna a_156_1344# avss nfet_06v0 ad=1.98p pd=7.2u as=1.98p ps=7.2u w=6.6u l=0.6u
X749 a_3012_2220# zpp a_2988_2220# avdd pfet_06v0 ad=1.98p pd=7.2u as=1.98p ps=7.2u w=6.6u l=0.6u
X750 a_n1164_1344# en bna avss nfet_06v0 ad=1.98p pd=7.2u as=1.98p ps=7.2u w=6.6u l=0.6u
X751 bpb bpb bpa_ avdd pfet_06v0 ad=1.98p pd=7.2u as=1.98p ps=7.2u w=6.6u l=0.6u
X752 a_3924_2220# zpp avdd avdd pfet_06v0 ad=1.98p pd=7.2u as=1.98p ps=7.2u w=6.6u l=0.6u
X753 bna enb a_n1212_1512# avss nfet_06v0 ad=1.98p pd=7.2u as=1.98p ps=7.2u w=6.6u l=0.6u
X754 ynp znp a_2196_1344# avss nfet_06v0 ad=1.98p pd=7.2u as=1.98p ps=7.2u w=6.6u l=0.6u
X755 a_636_1344# znp a_612_1344# avss nfet_06v0 ad=1.98p pd=7.2u as=1.98p ps=7.2u w=6.6u l=0.6u
X756 a_n948_1344# bna a_n972_1344# avss nfet_06v0 ad=1.98p pd=7.2u as=1.98p ps=7.2u w=6.6u l=0.6u
X757 a_3684_1512# znp ynm avss nfet_06v0 ad=1.98p pd=7.2u as=1.98p ps=7.2u w=6.6u l=0.6u
X758 a_660_1512# znp a_636_1512# avss nfet_06v0 ad=1.98p pd=7.2u as=1.98p ps=7.2u w=6.6u l=0.6u
X759 a_4740_1344# znm avss avss nfet_06v0 ad=1.98p pd=7.2u as=1.98p ps=7.2u w=6.6u l=0.6u
X760 a_n492_1344# a_n840_1339# a_n840_1339# avss nfet_06v0 ad=1.98p pd=7.2u as=1.98p ps=7.2u w=6.6u l=0.6u
X761 a_1884_2052# zpp a_1860_2052# avdd pfet_06v0 ad=1.98p pd=7.2u as=1.98p ps=7.2u w=6.6u l=0.6u
X762 a_1908_2220# zpp a_1884_2220# avdd pfet_06v0 ad=1.98p pd=7.2u as=1.98p ps=7.2u w=6.6u l=0.6u
X763 zpm zpp ypm avdd pfet_06v0 ad=1.98p pd=7.2u as=1.98p ps=7.2u w=6.6u l=0.6u
X764 a_n840_1339# a_n840_1339# a_n540_1512# avss nfet_06v0 ad=1.98p pd=7.2u as=1.98p ps=7.2u w=6.6u l=0.6u
X765 avdd zpp a_1428_2220# avdd pfet_06v0 ad=1.98p pd=7.2u as=1.98p ps=7.2u w=6.6u l=0.6u
X766 a_120_2047# a_120_2047# a_444_2052# avdd pfet_06v0 ad=1.98p pd=7.2u as=1.98p ps=7.2u w=6.6u l=0.6u
X767 bpa_ bpb bpb avdd pfet_06v0 ad=1.98p pd=7.2u as=1.98p ps=7.2u w=6.6u l=0.6u
X768 a_924_2052# bpa a_900_2052# avdd pfet_06v0 ad=1.98p pd=7.2u as=1.98p ps=7.2u w=6.6u l=0.6u
X769 bpb bpb bpa_ avdd pfet_06v0 ad=1.98p pd=7.2u as=1.98p ps=7.2u w=6.6u l=0.6u
X770 bpb bpb bpa_ avdd pfet_06v0 ad=1.98p pd=7.2u as=1.98p ps=7.2u w=6.6u l=0.6u
X771 a_3972_2220# zpp a_3948_2220# avdd pfet_06v0 ad=1.98p pd=7.2u as=1.98p ps=7.2u w=6.6u l=0.6u
X772 zpm bpb znm avdd pfet_06v0 ad=1.98p pd=7.2u as=1.98p ps=7.2u w=6.6u l=0.6u
X773 znp znp a_2244_1344# avss nfet_06v0 ad=1.98p pd=7.2u as=1.98p ps=7.2u w=6.6u l=0.6u
X774 ynp znp a_660_1344# avss nfet_06v0 ad=1.98p pd=7.2u as=1.98p ps=7.2u w=6.6u l=0.6u
X775 a_n1020_2220# bpa avdd avdd pfet_06v0 ad=1.98p pd=7.2u as=1.98p ps=7.2u w=6.6u l=0.6u
X776 a_948_2220# bpa a_924_2220# avdd pfet_06v0 ad=1.98p pd=7.2u as=1.98p ps=7.2u w=6.6u l=0.6u
X777 znm bpb zpm avdd pfet_06v0 ad=1.98p pd=7.2u as=1.98p ps=7.2u w=6.6u l=0.6u
X778 a_708_1512# znp ynp avss nfet_06v0 ad=1.98p pd=7.2u as=1.98p ps=7.2u w=6.6u l=0.6u
X779 a_2724_1344# bna avss avss nfet_06v0 ad=1.98p pd=7.2u as=1.98p ps=7.2u w=6.6u l=0.6u
X780 a_4788_1344# znm o avss nfet_06v0 ad=1.98p pd=7.2u as=1.98p ps=7.2u w=6.6u l=0.6u
X781 a_n540_1344# a_n840_1339# bna_ avss nfet_06v0 ad=1.98p pd=7.2u as=1.98p ps=7.2u w=6.6u l=0.6u
X782 bpa_ bpb bpb avdd pfet_06v0 ad=1.98p pd=7.2u as=1.98p ps=7.2u w=6.6u l=0.6u
X783 a_252_1512# bna a_228_1512# avss nfet_06v0 ad=1.98p pd=7.2u as=1.98p ps=7.2u w=6.6u l=0.6u
X784 a_2100_2052# bpa a_2076_2052# avdd pfet_06v0 ad=1.98p pd=7.2u as=1.98p ps=7.2u w=6.6u l=0.6u
X785 bna_ a_n840_1339# a_n588_1512# avss nfet_06v0 ad=1.98p pd=7.2u as=1.98p ps=7.2u w=6.6u l=0.6u
X786 a_4332_1344# znp a_4308_1344# avss nfet_06v0 ad=1.98p pd=7.2u as=1.98p ps=7.2u w=6.6u l=0.6u
X787 a_2748_1512# bna a_2724_1512# avss nfet_06v0 ad=1.98p pd=7.2u as=1.98p ps=7.2u w=6.6u l=0.6u
X788 a_4356_1512# znp a_4332_1512# avss nfet_06v0 ad=1.98p pd=7.2u as=1.98p ps=7.2u w=6.6u l=0.6u
X789 bpa_ bpa a_n396_2052# avdd pfet_06v0 ad=1.98p pd=7.2u as=1.98p ps=7.2u w=6.6u l=0.6u
X790 xp1 bpa a_948_2052# avdd pfet_06v0 ad=1.98p pd=7.2u as=1.98p ps=7.2u w=6.6u l=0.6u
X791 a_2556_2052# bpb znp avdd pfet_06v0 ad=1.98p pd=7.2u as=1.98p ps=7.2u w=6.6u l=0.6u
X792 znp bpb a_2556_2052# avdd pfet_06v0 ad=1.98p pd=7.2u as=1.98p ps=7.2u w=6.6u l=0.6u
X793 zpm bpb znm avdd pfet_06v0 ad=1.98p pd=7.2u as=1.98p ps=7.2u w=6.6u l=0.6u
X794 avss znm a_4788_1512# avss nfet_06v0 ad=1.98p pd=7.2u as=1.98p ps=7.2u w=6.6u l=0.6u
X795 ynm inp xp1 avdd pfet_06v0 ad=1.98p pd=7.2u as=1.98p ps=7.2u w=6.6u l=0.6u
X796 znm bpb zpm avdd pfet_06v0 ad=1.98p pd=7.2u as=1.98p ps=7.2u w=6.6u l=0.6u
X797 a_2124_2052# bpa a_2100_2220# avdd pfet_06v0 ad=1.98p pd=7.2u as=1.98p ps=7.2u w=6.6u l=0.6u
X798 a_2772_1344# bna a_2748_1344# avss nfet_06v0 ad=1.98p pd=7.2u as=1.98p ps=7.2u w=6.6u l=0.6u
X799 bpa_ bpb bpb avdd pfet_06v0 ad=1.98p pd=7.2u as=1.98p ps=7.2u w=6.6u l=0.6u
X800 bpa_ bpb bpb avdd pfet_06v0 ad=1.98p pd=7.2u as=1.98p ps=7.2u w=6.6u l=0.6u
X801 o zpm avdd avdd pfet_06v0 ad=1.98p pd=7.2u as=1.98p ps=7.2u w=6.6u l=0.6u
X802 a_2796_1512# bna a_2772_1512# avss nfet_06v0 ad=1.98p pd=7.2u as=1.98p ps=7.2u w=6.6u l=0.6u
X803 a_4404_1512# znp a_4380_1512# avss nfet_06v0 ad=1.98p pd=7.2u as=1.98p ps=7.2u w=6.6u l=0.6u
X804 a_2556_2052# bpb znp avdd pfet_06v0 ad=1.98p pd=7.2u as=1.98p ps=7.2u w=6.6u l=0.6u
X805 a_3420_1512# znp a_3396_1512# avss nfet_06v0 ad=1.98p pd=7.2u as=1.98p ps=7.2u w=6.6u l=0.6u
X806 a_2124_2052# bpb znp avdd pfet_06v0 ad=1.98p pd=7.2u as=1.98p ps=7.2u w=6.6u l=0.6u
X807 a_1620_2052# zpp a_1596_2052# avdd pfet_06v0 ad=1.98p pd=7.2u as=1.98p ps=7.2u w=6.6u l=0.6u
X808 ypp zpp zpp avdd pfet_06v0 ad=1.98p pd=7.2u as=1.98p ps=7.2u w=6.6u l=0.6u
X809 a_1380_1344# bna a_1356_1344# avss nfet_06v0 ad=1.98p pd=7.2u as=1.98p ps=7.2u w=6.6u l=0.6u
X810 o zpm avdd avdd pfet_06v0 ad=1.98p pd=7.2u as=1.98p ps=7.2u w=6.6u l=0.6u
X811 a_36_2052# bpa bpa_ avdd pfet_06v0 ad=1.98p pd=7.2u as=1.98p ps=7.2u w=6.6u l=0.6u
X812 a_60_2220# bpa a_36_2220# avdd pfet_06v0 ad=1.98p pd=7.2u as=1.98p ps=7.2u w=6.6u l=0.6u
X813 znm a_n840_1339# a_3876_1344# avss nfet_06v0 ad=1.98p pd=7.2u as=1.98p ps=7.2u w=6.6u l=0.6u
X814 xn inm a_1812_1344# avss nfet_06v0 ad=1.98p pd=7.2u as=1.98p ps=7.2u w=6.6u l=0.6u
X815 a_1860_1512# bna xn avss nfet_06v0 ad=1.98p pd=7.2u as=1.98p ps=7.2u w=6.6u l=0.6u
X816 a_3444_1344# znp a_3420_1344# avss nfet_06v0 ad=1.98p pd=7.2u as=1.98p ps=7.2u w=6.6u l=0.6u
X817 a_420_1344# bna a_396_1344# avss nfet_06v0 ad=1.98p pd=7.2u as=1.98p ps=7.2u w=6.6u l=0.6u
X818 a_3468_1512# znp a_3444_1512# avss nfet_06v0 ad=1.98p pd=7.2u as=1.98p ps=7.2u w=6.6u l=0.6u
X819 a_1668_2052# zpp avdd avdd pfet_06v0 ad=1.98p pd=7.2u as=1.98p ps=7.2u w=6.6u l=0.6u
X820 a_3012_1512# a_n840_1339# a_2892_1344# avss nfet_06v0 ad=1.98p pd=7.2u as=1.98p ps=7.2u w=6.6u l=0.6u
X821 a_1212_2052# bpa a_1188_2052# avdd pfet_06v0 ad=1.98p pd=7.2u as=1.98p ps=7.2u w=6.6u l=0.6u
X822 ypp zpp zpp avdd pfet_06v0 ad=1.98p pd=7.2u as=1.98p ps=7.2u w=6.6u l=0.6u
X823 a_n12_1512# bna a_n36_1512# avss nfet_06v0 ad=1.98p pd=7.2u as=1.98p ps=7.2u w=6.6u l=0.6u
X824 a_3924_1512# a_n840_1339# znm avss nfet_06v0 ad=1.98p pd=7.2u as=1.98p ps=7.2u w=6.6u l=0.6u
X825 a_3300_2220# zpp ypp avdd pfet_06v0 ad=1.98p pd=7.2u as=1.98p ps=7.2u w=6.6u l=0.6u
X826 a_84_2052# bpa a_60_2052# avdd pfet_06v0 ad=1.98p pd=7.2u as=1.98p ps=7.2u w=6.6u l=0.6u
X827 avdd bpa a_84_2220# avdd pfet_06v0 ad=1.98p pd=7.2u as=1.98p ps=7.2u w=6.6u l=0.6u
X828 a_1236_2220# bpa a_1212_2220# avdd pfet_06v0 ad=1.98p pd=7.2u as=1.98p ps=7.2u w=6.6u l=0.6u
X829 avdd en a_n1260_2052# avdd pfet_06v0 ad=1.98p pd=7.2u as=1.98p ps=7.2u w=6.6u l=0.6u
X830 a_1884_1344# bna a_1860_1344# avss nfet_06v0 ad=1.98p pd=7.2u as=1.98p ps=7.2u w=6.6u l=0.6u
X831 bpb bpb bpa_ avdd pfet_06v0 ad=1.98p pd=7.2u as=1.98p ps=7.2u w=6.6u l=0.6u
X832 zpm bpb znm avdd pfet_06v0 ad=1.98p pd=7.2u as=1.98p ps=7.2u w=6.6u l=0.6u
X833 ypm zpp zpm avdd pfet_06v0 ad=1.98p pd=7.2u as=1.98p ps=7.2u w=6.6u l=0.6u
X834 a_1908_1512# bna a_1884_1512# avss nfet_06v0 ad=1.98p pd=7.2u as=1.98p ps=7.2u w=6.6u l=0.6u
X835 a_3492_1344# znp a_3468_1344# avss nfet_06v0 ad=1.98p pd=7.2u as=1.98p ps=7.2u w=6.6u l=0.6u
X836 a_468_1344# bna a_444_1344# avss nfet_06v0 ad=1.98p pd=7.2u as=1.98p ps=7.2u w=6.6u l=0.6u
X837 xn bna a_1428_1512# avss nfet_06v0 ad=1.98p pd=7.2u as=1.98p ps=7.2u w=6.6u l=0.6u
X838 a_924_1344# znp a_900_1344# avss nfet_06v0 ad=1.98p pd=7.2u as=1.98p ps=7.2u w=6.6u l=0.6u
X839 a_n840_1339# a_n840_1339# a_n348_1344# avss nfet_06v0 ad=1.98p pd=7.2u as=1.98p ps=7.2u w=6.6u l=0.6u
X840 a_n348_1512# a_n840_1339# bna_ avss nfet_06v0 ad=1.98p pd=7.2u as=1.98p ps=7.2u w=6.6u l=0.6u
X841 a_n60_1512# bna bna_ avss nfet_06v0 ad=1.98p pd=7.2u as=1.98p ps=7.2u w=6.6u l=0.6u
X842 a_948_1512# znp a_924_1512# avss nfet_06v0 ad=1.98p pd=7.2u as=1.98p ps=7.2u w=6.6u l=0.6u
X843 a_4116_1344# znp znm avss nfet_06v0 ad=1.98p pd=7.2u as=1.98p ps=7.2u w=6.6u l=0.6u
X844 a_3972_1512# a_n840_1339# zpm avss nfet_06v0 ad=1.98p pd=7.2u as=1.98p ps=7.2u w=6.6u l=0.6u
X845 a_300_2052# a_120_2047# a_120_2047# avdd pfet_06v0 ad=1.98p pd=7.2u as=1.98p ps=7.2u w=6.6u l=0.6u
X846 a_n1020_1512# bna avss avss nfet_06v0 ad=1.98p pd=7.2u as=1.98p ps=7.2u w=6.6u l=0.6u
X847 ynm znp a_4116_1512# avss nfet_06v0 ad=1.98p pd=7.2u as=1.98p ps=7.2u w=6.6u l=0.6u
X848 a_1284_2220# zpp avdd avdd pfet_06v0 ad=1.98p pd=7.2u as=1.98p ps=7.2u w=6.6u l=0.6u
X849 enb en a_n1308_2052# avdd pfet_06v0 ad=1.98p pd=7.2u as=1.98p ps=7.2u w=6.6u l=0.6u
X850 a_n840_1339# a_n840_1339# a_n828_1512# avss nfet_06v0 ad=1.98p pd=7.2u as=1.98p ps=7.2u w=6.6u l=0.6u
X851 bpb bpb bpa_ avdd pfet_06v0 ad=1.98p pd=7.2u as=1.98p ps=7.2u w=6.6u l=0.6u
X852 a_2340_2052# bpa a_2316_2052# avdd pfet_06v0 ad=1.98p pd=7.2u as=1.98p ps=7.2u w=6.6u l=0.6u
X853 ypm zpp zpm avdd pfet_06v0 ad=1.98p pd=7.2u as=1.98p ps=7.2u w=6.6u l=0.6u
X854 ynm inp xp0 avdd pfet_06v0 ad=1.98p pd=7.2u as=1.98p ps=7.2u w=6.6u l=0.6u
X855 a_2100_1344# znp a_2076_1344# avss nfet_06v0 ad=1.98p pd=7.2u as=1.98p ps=7.2u w=6.6u l=0.6u
X856 xp0 inp ynm avdd pfet_06v0 ad=1.98p pd=7.2u as=1.98p ps=7.2u w=6.6u l=0.6u
X857 zpm en a_4836_2052# avdd pfet_06v0 ad=1.98p pd=7.2u as=1.98p ps=7.2u w=6.6u l=0.6u
X858 a_120_2047# a_120_2047# a_300_2220# avdd pfet_06v0 ad=1.98p pd=7.2u as=1.98p ps=7.2u w=6.6u l=0.6u
X859 bpa_ bpb bpb avdd pfet_06v0 ad=1.98p pd=7.2u as=1.98p ps=7.2u w=6.6u l=0.6u
X860 bpb bpb bpa_ avdd pfet_06v0 ad=1.98p pd=7.2u as=1.98p ps=7.2u w=6.6u l=0.6u
X861 zpp zpp ypp avdd pfet_06v0 ad=1.98p pd=7.2u as=1.98p ps=7.2u w=6.6u l=0.6u
X862 a_2556_1344# znp a_2532_1344# avss nfet_06v0 ad=1.98p pd=7.2u as=1.98p ps=7.2u w=6.6u l=0.6u
X863 a_972_1344# znp a_948_1344# avss nfet_06v0 ad=1.98p pd=7.2u as=1.98p ps=7.2u w=6.6u l=0.6u
X864 bna_ a_n840_1339# a_n396_1344# avss nfet_06v0 ad=1.98p pd=7.2u as=1.98p ps=7.2u w=6.6u l=0.6u
X865 avdd zpp a_4404_2220# avdd pfet_06v0 ad=1.98p pd=7.2u as=1.98p ps=7.2u w=6.6u l=0.6u
X866 a_996_1512# znp a_972_1512# avss nfet_06v0 ad=1.98p pd=7.2u as=1.98p ps=7.2u w=6.6u l=0.6u
X867 a_4164_1344# znp ynm avss nfet_06v0 ad=1.98p pd=7.2u as=1.98p ps=7.2u w=6.6u l=0.6u
X868 a_2580_1512# znp a_2556_1512# avss nfet_06v0 ad=1.98p pd=7.2u as=1.98p ps=7.2u w=6.6u l=0.6u
X869 znm znp a_4164_1512# avss nfet_06v0 ad=1.98p pd=7.2u as=1.98p ps=7.2u w=6.6u l=0.6u
X870 a_2124_1512# znp a_2100_1512# avss nfet_06v0 ad=1.98p pd=7.2u as=1.98p ps=7.2u w=6.6u l=0.6u
X871 a_2388_2052# bpa avdd avdd pfet_06v0 ad=1.98p pd=7.2u as=1.98p ps=7.2u w=6.6u l=0.6u
X872 bna_ bna a_n876_1512# avss nfet_06v0 ad=1.98p pd=7.2u as=1.98p ps=7.2u w=6.6u l=0.6u
X873 a_12_1344# bna a_n12_1344# avss nfet_06v0 ad=1.98p pd=7.2u as=1.98p ps=7.2u w=6.6u l=0.6u
X874 a_804_2052# bpa xp0 avdd pfet_06v0 ad=1.98p pd=7.2u as=1.98p ps=7.2u w=6.6u l=0.6u
X875 a_4644_1512# znm avss avss nfet_06v0 ad=1.98p pd=7.2u as=1.98p ps=7.2u w=6.6u l=0.6u
X876 avdd en a_4884_2052# avdd pfet_06v0 ad=3.96p pd=14.4u as=1.98p ps=7.2u w=6.6u l=0.6u
X877 a_120_2047# a_120_2047# a_348_2220# avdd pfet_06v0 ad=1.98p pd=7.2u as=1.98p ps=7.2u w=6.6u l=0.6u
X878 bpa_ bpb bpb avdd pfet_06v0 ad=1.98p pd=7.2u as=1.98p ps=7.2u w=6.6u l=0.6u
X879 ypp zpp zpp avdd pfet_06v0 ad=1.98p pd=7.2u as=1.98p ps=7.2u w=6.6u l=0.6u
X880 bpb bpb bpa_ avdd pfet_06v0 ad=1.98p pd=7.2u as=1.98p ps=7.2u w=6.6u l=0.6u
X881 zpp zpp ypp avdd pfet_06v0 ad=1.98p pd=7.2u as=1.98p ps=7.2u w=6.6u l=0.6u
X882 o zpm avdd avdd pfet_06v0 ad=1.98p pd=7.2u as=1.98p ps=7.2u w=6.6u l=0.6u
X883 a_2604_1344# znp a_2580_1344# avss nfet_06v0 ad=1.98p pd=7.2u as=1.98p ps=7.2u w=6.6u l=0.6u
X884 avdd zpm o avdd pfet_06v0 ad=1.98p pd=7.2u as=1.98p ps=7.2u w=6.6u l=0.6u
X885 a_2412_2220# bpa a_2388_2220# avdd pfet_06v0 ad=1.98p pd=7.2u as=1.98p ps=7.2u w=6.6u l=0.6u
X886 a_1620_1344# inp ypm avss nfet_06v0 ad=1.98p pd=7.2u as=1.98p ps=7.2u w=6.6u l=0.6u
X887 a_2172_1512# znp a_2148_1512# avss nfet_06v0 ad=1.98p pd=7.2u as=1.98p ps=7.2u w=6.6u l=0.6u
X888 a_3228_1344# bna a_3204_1344# avss nfet_06v0 ad=1.98p pd=7.2u as=1.98p ps=7.2u w=6.6u l=0.6u
X889 a_36_1344# bna a_12_1344# avss nfet_06v0 ad=1.98p pd=7.2u as=1.98p ps=7.2u w=6.6u l=0.6u
X890 a_4692_1512# znm o avss nfet_06v0 ad=1.98p pd=7.2u as=1.98p ps=7.2u w=6.6u l=0.6u
X891 a_60_1512# bna a_36_1512# avss nfet_06v0 ad=1.98p pd=7.2u as=1.98p ps=7.2u w=6.6u l=0.6u
X892 ypp zpp zpp avdd pfet_06v0 ad=1.98p pd=7.2u as=1.98p ps=7.2u w=6.6u l=0.6u
X893 a_3060_2052# zpp avdd avdd pfet_06v0 ad=1.98p pd=7.2u as=1.98p ps=7.2u w=6.6u l=0.6u
X894 xp1 inp ynm avdd pfet_06v0 ad=1.98p pd=7.2u as=1.98p ps=7.2u w=6.6u l=0.6u
X895 ypm zpp zpm avdd pfet_06v0 ad=1.98p pd=7.2u as=1.98p ps=7.2u w=6.6u l=0.6u
X896 a_1668_1344# inp xn avss nfet_06v0 ad=1.98p pd=7.2u as=1.98p ps=7.2u w=6.6u l=0.6u
X897 zpm zpp ypm avdd pfet_06v0 ad=1.98p pd=7.2u as=1.98p ps=7.2u w=6.6u l=0.6u
X898 a_3276_1344# bna a_3252_1344# avss nfet_06v0 ad=1.98p pd=7.2u as=1.98p ps=7.2u w=6.6u l=0.6u
X899 a_1212_1344# znp a_1188_1344# avss nfet_06v0 ad=1.98p pd=7.2u as=1.98p ps=7.2u w=6.6u l=0.6u
X900 a_1236_1512# znp a_1212_1512# avss nfet_06v0 ad=1.98p pd=7.2u as=1.98p ps=7.2u w=6.6u l=0.6u
X901 a_84_1344# bna a_60_1344# avss nfet_06v0 ad=1.98p pd=7.2u as=1.98p ps=7.2u w=6.6u l=0.6u
X902 a_3300_1512# bna a_3276_1512# avss nfet_06v0 ad=1.98p pd=7.2u as=1.98p ps=7.2u w=6.6u l=0.6u
X903 avss bna a_84_1512# avss nfet_06v0 ad=1.98p pd=7.2u as=1.98p ps=7.2u w=6.6u l=0.6u
X904 avss en a_n1260_1344# avss nfet_06v0 ad=1.98p pd=7.2u as=1.98p ps=7.2u w=6.6u l=0.6u
X905 a_1500_2052# zpp a_1476_2052# avdd pfet_06v0 ad=1.98p pd=7.2u as=1.98p ps=7.2u w=6.6u l=0.6u
X906 a_3732_1344# a_n840_1339# znm avss nfet_06v0 ad=1.98p pd=7.2u as=1.98p ps=7.2u w=6.6u l=0.6u
X907 a_n108_1344# a_n840_1339# a_n840_1339# avss nfet_06v0 ad=1.98p pd=7.2u as=1.98p ps=7.2u w=6.6u l=0.6u
X908 a_3108_2052# zpp a_3084_2052# avdd pfet_06v0 ad=1.98p pd=7.2u as=1.98p ps=7.2u w=6.6u l=0.6u
X909 zpm a_n840_1339# a_3732_1512# avss nfet_06v0 ad=1.98p pd=7.2u as=1.98p ps=7.2u w=6.6u l=0.6u
X910 ynm inp xp1 avdd pfet_06v0 ad=1.98p pd=7.2u as=1.98p ps=7.2u w=6.6u l=0.6u
X911 xp1 inp ynm avdd pfet_06v0 ad=1.98p pd=7.2u as=1.98p ps=7.2u w=6.6u l=0.6u
X912 a_n1068_2052# en bpa avdd pfet_06v0 ad=1.98p pd=7.2u as=1.98p ps=7.2u w=6.6u l=0.6u
X913 a_1956_2052# zpp ypp avdd pfet_06v0 ad=1.98p pd=7.2u as=1.98p ps=7.2u w=6.6u l=0.6u
X914 a_1980_2220# zpp a_1956_2220# avdd pfet_06v0 ad=1.98p pd=7.2u as=1.98p ps=7.2u w=6.6u l=0.6u
X915 znm bpb zpm avdd pfet_06v0 ad=1.98p pd=7.2u as=1.98p ps=7.2u w=6.6u l=0.6u
X916 zpm bpb znm avdd pfet_06v0 ad=1.98p pd=7.2u as=1.98p ps=7.2u w=6.6u l=0.6u
X917 a_540_2052# bpa a_516_2052# avdd pfet_06v0 ad=1.98p pd=7.2u as=1.98p ps=7.2u w=6.6u l=0.6u
X918 a_1524_2220# zpp a_1500_2220# avdd pfet_06v0 ad=1.98p pd=7.2u as=1.98p ps=7.2u w=6.6u l=0.6u
X919 bpb bna a_276_1344# avss nfet_06v0 ad=1.98p pd=7.2u as=1.98p ps=7.2u w=6.6u l=0.6u
X920 ypp zpp a_3108_2220# avdd pfet_06v0 ad=1.98p pd=7.2u as=1.98p ps=7.2u w=6.6u l=0.6u
X921 a_n396_2052# bpa a_n420_2052# avdd pfet_06v0 ad=1.98p pd=7.2u as=1.98p ps=7.2u w=6.6u l=0.6u
X922 a_1284_1512# bna avss avss nfet_06v0 ad=1.98p pd=7.2u as=1.98p ps=7.2u w=6.6u l=0.6u
X923 enb en a_n1308_1344# avss nfet_06v0 ad=1.98p pd=7.2u as=1.98p ps=7.2u w=6.6u l=0.6u
X924 a_2340_1344# znp ynp avss nfet_06v0 ad=1.98p pd=7.2u as=1.98p ps=7.2u w=6.6u l=0.6u
X925 a_756_1344# znp a_732_1344# avss nfet_06v0 ad=1.98p pd=7.2u as=1.98p ps=7.2u w=6.6u l=0.6u
X926 a_n156_1344# a_n840_1339# bna_ avss nfet_06v0 ad=1.98p pd=7.2u as=1.98p ps=7.2u w=6.6u l=0.6u
X927 bpa enb a_n1116_2220# avdd pfet_06v0 ad=1.98p pd=7.2u as=1.98p ps=7.2u w=6.6u l=0.6u
X928 znm a_n840_1339# a_3780_1512# avss nfet_06v0 ad=1.98p pd=7.2u as=1.98p ps=7.2u w=6.6u l=0.6u
X929 ynp inm xp1 avdd pfet_06v0 ad=1.98p pd=7.2u as=1.98p ps=7.2u w=6.6u l=0.6u
X930 a_780_1512# znp a_756_1512# avss nfet_06v0 ad=1.98p pd=7.2u as=1.98p ps=7.2u w=6.6u l=0.6u
X931 znm enb a_4836_1344# avss nfet_06v0 ad=1.98p pd=7.2u as=1.98p ps=7.2u w=6.6u l=0.6u
X932 a_n840_1339# a_n840_1339# a_n636_1344# avss nfet_06v0 ad=1.98p pd=7.2u as=1.98p ps=7.2u w=6.6u l=0.6u
X933 a_2004_2052# zpp a_1980_2052# avdd pfet_06v0 ad=1.98p pd=7.2u as=1.98p ps=7.2u w=6.6u l=0.6u
X934 a_324_1512# bna bpb avss nfet_06v0 ad=1.98p pd=7.2u as=1.98p ps=7.2u w=6.6u l=0.6u
X935 a_n636_1512# a_n840_1339# bna_ avss nfet_06v0 ad=1.98p pd=7.2u as=1.98p ps=7.2u w=6.6u l=0.6u
X936 a_2820_1512# bna a_2796_1512# avss nfet_06v0 ad=1.98p pd=7.2u as=1.98p ps=7.2u w=6.6u l=0.6u
X937 xp0 bpa a_564_2052# avdd pfet_06v0 ad=1.98p pd=7.2u as=1.98p ps=7.2u w=6.6u l=0.6u
X938 avss znp a_4404_1512# avss nfet_06v0 ad=1.98p pd=7.2u as=1.98p ps=7.2u w=6.6u l=0.6u
X939 a_1572_2220# zpp ypm avdd pfet_06v0 ad=1.98p pd=7.2u as=1.98p ps=7.2u w=6.6u l=0.6u
X940 a_120_2047# a_120_2047# avdd avdd pfet_06v0 ad=1.98p pd=7.2u as=1.98p ps=7.2u w=6.6u l=0.6u
X941 a_n444_2052# bpa avdd avdd pfet_06v0 ad=1.98p pd=7.2u as=1.98p ps=7.2u w=6.6u l=0.6u
X942 a_2628_2052# bpa a_2556_2052# avdd pfet_06v0 ad=1.98p pd=7.2u as=1.98p ps=7.2u w=6.6u l=0.6u
X943 avdd bpa a_n492_2220# avdd pfet_06v0 ad=1.98p pd=7.2u as=1.98p ps=7.2u w=6.6u l=0.6u
X944 a_156_2220# a_120_2047# a_120_2047# avdd pfet_06v0 ad=1.98p pd=7.2u as=1.98p ps=7.2u w=6.6u l=0.6u
X945 znm bpb zpm avdd pfet_06v0 ad=1.98p pd=7.2u as=1.98p ps=7.2u w=6.6u l=0.6u
X946 a_2388_1344# znp znp avss nfet_06v0 ad=1.98p pd=7.2u as=1.98p ps=7.2u w=6.6u l=0.6u
X947 a_804_1344# znp a_780_1344# avss nfet_06v0 ad=1.98p pd=7.2u as=1.98p ps=7.2u w=6.6u l=0.6u
X948 bpa_ enb a_n1164_2220# avdd pfet_06v0 ad=1.98p pd=7.2u as=1.98p ps=7.2u w=6.6u l=0.6u
X949 ynp inm xp0 avdd pfet_06v0 ad=1.98p pd=7.2u as=1.98p ps=7.2u w=6.6u l=0.6u
X950 zpm bpb znm avdd pfet_06v0 ad=1.98p pd=7.2u as=1.98p ps=7.2u w=6.6u l=0.6u
X951 bpa_ bpb bpb avdd pfet_06v0 ad=1.98p pd=7.2u as=1.98p ps=7.2u w=6.6u l=0.6u
X952 avss enb a_4884_1344# avss nfet_06v0 ad=3.96p pd=14.4u as=1.98p ps=7.2u w=6.6u l=0.6u
X953 bna_ a_n840_1339# a_n684_1344# avss nfet_06v0 ad=1.98p pd=7.2u as=1.98p ps=7.2u w=6.6u l=0.6u
X954 bpb bpb bpa_ avdd pfet_06v0 ad=1.98p pd=7.2u as=1.98p ps=7.2u w=6.6u l=0.6u
X955 a_372_1512# bna a_348_1512# avss nfet_06v0 ad=1.98p pd=7.2u as=1.98p ps=7.2u w=6.6u l=0.6u
X956 a_2844_1344# bna a_2820_1344# avss nfet_06v0 ad=1.98p pd=7.2u as=1.98p ps=7.2u w=6.6u l=0.6u
X957 avdd zpm o avdd pfet_06v0 ad=1.98p pd=7.2u as=1.98p ps=7.2u w=6.6u l=0.6u
X958 a_n684_1512# a_n840_1339# a_n840_1339# avss nfet_06v0 ad=1.98p pd=7.2u as=1.98p ps=7.2u w=6.6u l=0.6u
X959 a_4452_1344# znm avss avss nfet_06v0 ad=1.98p pd=7.2u as=1.98p ps=7.2u w=6.6u l=0.6u
X960 a_2868_1512# bna a_2844_1512# avss nfet_06v0 ad=1.98p pd=7.2u as=1.98p ps=7.2u w=6.6u l=0.6u
X961 o znm a_4452_1512# avss nfet_06v0 ad=1.98p pd=7.2u as=1.98p ps=7.2u w=6.6u l=0.6u
X962 ynp znp a_2388_1512# avss nfet_06v0 ad=1.98p pd=7.2u as=1.98p ps=7.2u w=6.6u l=0.6u
X963 a_2676_2052# bpa a_2652_2052# avdd pfet_06v0 ad=1.98p pd=7.2u as=1.98p ps=7.2u w=6.6u l=0.6u
X964 a_204_2220# a_120_2047# a_120_2047# avdd pfet_06v0 ad=1.98p pd=7.2u as=1.98p ps=7.2u w=6.6u l=0.6u
X965 avdd bpa a_2676_2220# avdd pfet_06v0 ad=1.98p pd=7.2u as=1.98p ps=7.2u w=6.6u l=0.6u
X966 ypm zpp zpm avdd pfet_06v0 ad=1.98p pd=7.2u as=1.98p ps=7.2u w=6.6u l=0.6u
X967 znp bpb a_2220_2052# avdd pfet_06v0 ad=1.98p pd=7.2u as=1.98p ps=7.2u w=6.6u l=0.6u
X968 zpm zpp ypm avdd pfet_06v0 ad=1.98p pd=7.2u as=1.98p ps=7.2u w=6.6u l=0.6u
X969 a_n972_2220# bpa a_n996_2220# avdd pfet_06v0 ad=1.98p pd=7.2u as=1.98p ps=7.2u w=6.6u l=0.6u
X970 a_2892_1344# bna a_2868_1344# avss nfet_06v0 ad=1.98p pd=7.2u as=1.98p ps=7.2u w=6.6u l=0.6u
X971 avdd zpm o avdd pfet_06v0 ad=1.98p pd=7.2u as=1.98p ps=7.2u w=6.6u l=0.6u
X972 a_3060_1344# a_n840_1339# zpp avss nfet_06v0 ad=1.98p pd=7.2u as=1.98p ps=7.2u w=6.6u l=0.6u
X973 a_1020_1512# znp a_996_1512# avss nfet_06v0 ad=1.98p pd=7.2u as=1.98p ps=7.2u w=6.6u l=0.6u
X974 a_3516_1344# znp a_3492_1344# avss nfet_06v0 ad=1.98p pd=7.2u as=1.98p ps=7.2u w=6.6u l=0.6u
X975 a_3540_1512# znp a_3516_1512# avss nfet_06v0 ad=1.98p pd=7.2u as=1.98p ps=7.2u w=6.6u l=0.6u
X976 a_2292_2220# bpa a_2220_2052# avdd pfet_06v0 ad=1.98p pd=7.2u as=1.98p ps=7.2u w=6.6u l=0.6u
X977 ypm zpp a_1716_2052# avdd pfet_06v0 ad=1.98p pd=7.2u as=1.98p ps=7.2u w=6.6u l=0.6u
X978 a_3348_2052# zpp a_3324_2052# avdd pfet_06v0 ad=1.98p pd=7.2u as=1.98p ps=7.2u w=6.6u l=0.6u
X979 ypp inm a_1476_1344# avss nfet_06v0 ad=1.98p pd=7.2u as=1.98p ps=7.2u w=6.6u l=0.6u
X980 a_3108_1344# a_n840_1339# a_2892_1344# avss nfet_06v0 ad=1.98p pd=7.2u as=1.98p ps=7.2u w=6.6u l=0.6u
X981 a_1044_1344# znp a_1020_1344# avss nfet_06v0 ad=1.98p pd=7.2u as=1.98p ps=7.2u w=6.6u l=0.6u
X982 a_n1308_2052# en avdd avdd pfet_06v0 ad=1.98p pd=7.2u as=3.96p ps=14.4u w=6.6u l=0.6u
X983 ynm znp a_1044_1512# avss nfet_06v0 ad=1.98p pd=7.2u as=1.98p ps=7.2u w=6.6u l=0.6u
X984 a_1956_1344# bna a_1932_1344# avss nfet_06v0 ad=1.98p pd=7.2u as=1.98p ps=7.2u w=6.6u l=0.6u
X985 a_n1068_1344# enb bna avss nfet_06v0 ad=1.98p pd=7.2u as=1.98p ps=7.2u w=6.6u l=0.6u
X986 a_3828_2220# zpp ypm avdd pfet_06v0 ad=1.98p pd=7.2u as=1.98p ps=7.2u w=6.6u l=0.6u
X987 a_1980_1512# bna a_1956_1512# avss nfet_06v0 ad=1.98p pd=7.2u as=1.98p ps=7.2u w=6.6u l=0.6u
X988 ynm znp a_3540_1344# avss nfet_06v0 ad=1.98p pd=7.2u as=1.98p ps=7.2u w=6.6u l=0.6u
X989 a_1524_1512# inm ypp avss nfet_06v0 ad=1.98p pd=7.2u as=1.98p ps=7.2u w=6.6u l=0.6u
X990 a_540_1344# znp a_516_1344# avss nfet_06v0 ad=1.98p pd=7.2u as=1.98p ps=7.2u w=6.6u l=0.6u
X991 a_3588_1512# znp ynm avss nfet_06v0 ad=1.98p pd=7.2u as=1.98p ps=7.2u w=6.6u l=0.6u
X992 m3_4968_1416# m3_5016_1416# rm3 r_width=0.6u r_length=0.6u
X993 a_1788_2052# zpp a_1764_2052# avdd pfet_06v0 ad=1.98p pd=7.2u as=1.98p ps=7.2u w=6.6u l=0.6u
X994 a_n396_1344# a_n840_1339# a_n840_1339# avss nfet_06v0 ad=1.98p pd=7.2u as=1.98p ps=7.2u w=6.6u l=0.6u
X995 zpp a_n840_1339# a_3108_1512# avss nfet_06v0 ad=1.98p pd=7.2u as=1.98p ps=7.2u w=6.6u l=0.6u
X996 a_3396_2052# zpp avdd avdd pfet_06v0 ad=1.98p pd=7.2u as=1.98p ps=7.2u w=6.6u l=0.6u
X997 a_1332_2052# zpp a_1308_2052# avdd pfet_06v0 ad=1.98p pd=7.2u as=1.98p ps=7.2u w=6.6u l=0.6u
X998 bna en a_n1116_1512# avss nfet_06v0 ad=1.98p pd=7.2u as=1.98p ps=7.2u w=6.6u l=0.6u
X999 a_1092_1344# znp ynm avss nfet_06v0 ad=1.98p pd=7.2u as=1.98p ps=7.2u w=6.6u l=0.6u
X1000 ypp zpp a_1332_2220# avdd pfet_06v0 ad=1.98p pd=7.2u as=1.98p ps=7.2u w=6.6u l=0.6u
X1001 bpa_ bpb bpb avdd pfet_06v0 ad=1.98p pd=7.2u as=1.98p ps=7.2u w=6.6u l=0.6u
X1002 a_3852_2052# zpp a_3828_2052# avdd pfet_06v0 ad=1.98p pd=7.2u as=1.98p ps=7.2u w=6.6u l=0.6u
X1003 a_2004_1344# bna a_1980_1344# avss nfet_06v0 ad=1.98p pd=7.2u as=1.98p ps=7.2u w=6.6u l=0.6u
X1004 a_1812_2220# zpp a_1788_2220# avdd pfet_06v0 ad=1.98p pd=7.2u as=1.98p ps=7.2u w=6.6u l=0.6u
X1005 a_3876_2220# zpp a_3852_2220# avdd pfet_06v0 ad=1.98p pd=7.2u as=1.98p ps=7.2u w=6.6u l=0.6u
X1006 a_828_2052# bpa a_804_2052# avdd pfet_06v0 ad=1.98p pd=7.2u as=1.98p ps=7.2u w=6.6u l=0.6u
X1007 zpm zpp ypm avdd pfet_06v0 ad=1.98p pd=7.2u as=1.98p ps=7.2u w=6.6u l=0.6u
X1008 a_1572_1512# inp xn avss nfet_06v0 ad=1.98p pd=7.2u as=1.98p ps=7.2u w=6.6u l=0.6u
X1009 a_588_1344# znp a_564_1344# avss nfet_06v0 ad=1.98p pd=7.2u as=1.98p ps=7.2u w=6.6u l=0.6u
X1010 ib bnb rm3 r_width=0.6u r_length=0.6u
X1011 a_132_1344# bna avss avss nfet_06v0 ad=1.98p pd=7.2u as=1.98p ps=7.2u w=6.6u l=0.6u
X1012 bpa_ bpb bpb avdd pfet_06v0 ad=1.98p pd=7.2u as=1.98p ps=7.2u w=6.6u l=0.6u
X1013 a_2628_1344# znp a_2604_1344# avss nfet_06v0 ad=1.98p pd=7.2u as=1.98p ps=7.2u w=6.6u l=0.6u
X1014 a_n444_1344# a_n840_1339# bna_ avss nfet_06v0 ad=1.98p pd=7.2u as=1.98p ps=7.2u w=6.6u l=0.6u
X1015 bna_ a_n840_1339# a_n492_1512# avss nfet_06v0 ad=1.98p pd=7.2u as=1.98p ps=7.2u w=6.6u l=0.6u
X1016 a_156_1512# bna a_132_1512# avss nfet_06v0 ad=1.98p pd=7.2u as=1.98p ps=7.2u w=6.6u l=0.6u
X1017 ynm znp a_4212_1344# avss nfet_06v0 ad=1.98p pd=7.2u as=1.98p ps=7.2u w=6.6u l=0.6u
X1018 bna_ en a_n1164_1512# avss nfet_06v0 ad=1.98p pd=7.2u as=1.98p ps=7.2u w=6.6u l=0.6u
X1019 a_n900_1344# bna a_n924_1344# avss nfet_06v0 ad=1.98p pd=7.2u as=1.98p ps=7.2u w=6.6u l=0.6u
X1020 a_4260_1512# znp ynm avss nfet_06v0 ad=1.98p pd=7.2u as=1.98p ps=7.2u w=6.6u l=0.6u
X1021 a_1404_2220# zpp a_1380_2220# avdd pfet_06v0 ad=1.98p pd=7.2u as=1.98p ps=7.2u w=6.6u l=0.6u
X1022 a_612_1512# znp a_588_1512# avss nfet_06v0 ad=1.98p pd=7.2u as=1.98p ps=7.2u w=6.6u l=0.6u
X1023 bpa_ bpb bpb avdd pfet_06v0 ad=1.98p pd=7.2u as=1.98p ps=7.2u w=6.6u l=0.6u
X1024 a_2460_2052# bpa a_2436_2052# avdd pfet_06v0 ad=1.98p pd=7.2u as=1.98p ps=7.2u w=6.6u l=0.6u
X1025 a_n924_1512# bna a_n948_1512# avss nfet_06v0 ad=1.98p pd=7.2u as=1.98p ps=7.2u w=6.6u l=0.6u
X1026 avdd bpa a_852_2052# avdd pfet_06v0 ad=1.98p pd=7.2u as=1.98p ps=7.2u w=6.6u l=0.6u
X1027 zpm zpp ypm avdd pfet_06v0 ad=1.98p pd=7.2u as=1.98p ps=7.2u w=6.6u l=0.6u
X1028 avss znm a_4692_1512# avss nfet_06v0 ad=1.98p pd=7.2u as=1.98p ps=7.2u w=6.6u l=0.6u
X1029 a_900_2220# bpa avdd avdd pfet_06v0 ad=1.98p pd=7.2u as=1.98p ps=7.2u w=6.6u l=0.6u
X1030 avdd zpp a_2004_2220# avdd pfet_06v0 ad=1.98p pd=7.2u as=1.98p ps=7.2u w=6.6u l=0.6u
X1031 bpb bpb bpa_ avdd pfet_06v0 ad=1.98p pd=7.2u as=1.98p ps=7.2u w=6.6u l=0.6u
X1032 zpp zpp ypp avdd pfet_06v0 ad=1.98p pd=7.2u as=1.98p ps=7.2u w=6.6u l=0.6u
X1033 bpa_ bpb bpb avdd pfet_06v0 ad=1.98p pd=7.2u as=1.98p ps=7.2u w=6.6u l=0.6u
X1034 a_444_2220# a_120_2047# a_120_2047# avdd pfet_06v0 ad=1.98p pd=7.2u as=1.98p ps=7.2u w=6.6u l=0.6u
X1035 ypp zpp zpp avdd pfet_06v0 ad=1.98p pd=7.2u as=1.98p ps=7.2u w=6.6u l=0.6u
X1036 avdd zpm o avdd pfet_06v0 ad=1.98p pd=7.2u as=1.98p ps=7.2u w=6.6u l=0.6u
X1037 a_2676_1344# znp a_2652_1344# avss nfet_06v0 ad=1.98p pd=7.2u as=1.98p ps=7.2u w=6.6u l=0.6u
X1038 o zpm avdd avdd pfet_06v0 ad=1.98p pd=7.2u as=1.98p ps=7.2u w=6.6u l=0.6u
X1039 a_204_1512# bna a_180_1512# avss nfet_06v0 ad=1.98p pd=7.2u as=1.98p ps=7.2u w=6.6u l=0.6u
X1040 a_4284_1344# znp a_4260_1344# avss nfet_06v0 ad=1.98p pd=7.2u as=1.98p ps=7.2u w=6.6u l=0.6u
X1041 avss znp a_2676_1512# avss nfet_06v0 ad=1.98p pd=7.2u as=1.98p ps=7.2u w=6.6u l=0.6u
X1042 bpb bpb bpa_ avdd pfet_06v0 ad=1.98p pd=7.2u as=1.98p ps=7.2u w=6.6u l=0.6u
X1043 a_4308_1512# znp a_4284_1512# avss nfet_06v0 ad=1.98p pd=7.2u as=1.98p ps=7.2u w=6.6u l=0.6u
C0 m4_624_2028# avss 1.32738f
C1 m4_768_1320# avdd 1.36255f
C2 zpm o 42.5273f
C3 m4_n1344_1320# avss 2.7687f
C4 bna avdd 1.14142f
C5 m4_3168_1320# avss 2.40624f
C6 m4_2640_2028# avdd 2.36307f
C7 ynp avss 15.9481f
C8 ynm avdd 4.96002f
C9 m4_528_2028# avss 1.32738f
C10 m4_672_1320# avdd 1.36255f
C11 m4_n1440_1320# avss 1.88995f
C12 m4_3072_1320# avss 2.40179f
C13 xp1 inm 1.56839f
C14 m4_2544_2028# avdd 2.29172f
C15 m4_432_2028# avss 1.32738f
C16 m4_576_1320# avdd 1.36255f
C17 m4_4944_2028# avss 1.32738f
C18 bpb zpp 7.77125f
C19 m4_2976_1320# avss 2.40179f
C20 enb en 5.85198f
C21 bpb avdd 62.8505f
C22 m4_2448_2028# avdd 2.29989f
C23 m4_336_2028# avss 1.32738f
C24 m4_480_1320# avdd 1.36255f
C25 m4_4848_2028# avss 1.32738f
C26 m4_4992_1320# avdd 1.39478f
C27 bpb a_120_2047# 1.19718f
C28 m4_2880_1320# avss 2.40624f
C29 a_n840_1339# avss 52.4304f
C30 bna en 1.5757f
C31 m4_2352_2028# avdd 2.4697f
C32 m4_240_2028# avss 1.32738f
C33 m4_384_1320# avdd 1.36255f
C34 m4_4752_2028# avss 1.32738f
C35 m4_4896_1320# avdd 1.37777f
C36 xp0 inp 1.56737f
C37 ynp inm 5.36401f
C38 m4_2784_1320# avss 2.44294f
C39 m4_2256_2028# avdd 2.29989f
C40 zpp avss 4.45223f
C41 m4_144_2028# avss 1.32738f
C42 m4_288_1320# avdd 1.35883f
C43 m4_4656_2028# avss 1.32738f
C44 m4_4800_1320# avdd 1.36353f
C45 m4_2688_1320# avss 2.57131f
C46 avdd avss 0.80008p
C47 m4_2160_2028# avdd 2.29172f
C48 m4_48_2028# avss 1.32738f
C49 bpb en 1.95348f
C50 m4_192_1320# avdd 1.36255f
C51 m4_4560_2028# avss 1.32738f
C52 m4_4704_1320# avdd 1.36255f
C53 m4_2592_1320# avss 2.35527f
C54 m4_2064_2028# avdd 2.36307f
C55 m4_n48_2028# avss 1.32738f
C56 m4_96_1320# avdd 1.36255f
C57 m4_4464_2028# avss 1.32738f
C58 m4_4608_1320# avdd 1.36255f
C59 m4_2496_1320# avss 2.27967f
C60 ynm inp 6.43281f
C61 m4_1968_2028# avdd 2.35715f
C62 m4_n144_2028# avss 1.32738f
C63 m4_0_1320# avdd 1.36255f
C64 m4_4368_2028# avss 1.32738f
C65 m4_4512_1320# avdd 1.36255f
C66 m4_2400_1320# avss 2.25906f
C67 avdd inm 14.2813f
C68 avss en 8.86542f
C69 m4_1872_2028# avdd 2.35715f
C70 a_2124_2052# znp 1.6227f
C71 m4_n240_2028# avss 1.32738f
C72 m4_n96_1320# avdd 1.36255f
C73 m4_4272_2028# avss 1.32738f
C74 m4_4416_1320# avdd 1.36255f
C75 m4_2304_1320# avss 2.25906f
C76 enb znm 2.13581f
C77 m4_1776_2028# avdd 2.34318f
C78 m4_n336_2028# avss 1.32738f
C79 m4_n192_1320# avdd 1.36255f
C80 a_n840_1339# zpm 5.24095f
C81 m4_4176_2028# avss 1.32738f
C82 m4_4320_1320# avdd 1.36255f
C83 bpb a_2556_2052# 1.13629f
C84 m4_2208_1320# avss 2.26351f
C85 ynp o 1.37596f
C86 ynm znm 2.72714f
C87 m4_1680_2028# avdd 2.33702f
C88 zpp ypm 12.546f
C89 m4_n432_2028# avss 1.32738f
C90 m4_n288_1320# avdd 1.36255f
C91 m4_4080_2028# avss 1.32738f
C92 m4_4224_1320# avdd 1.36255f
C93 bpb a_2460_2052# 1.13629f
C94 m4_2112_1320# avss 2.30463f
C95 ypm avdd 25.7923f
C96 zpp zpm 4.85362f
C97 m4_1584_2028# avdd 2.33702f
C98 m4_n528_2028# avss 1.32738f
C99 m4_n384_1320# avdd 1.36255f
C100 avss inp 12.5704f
C101 avdd zpm 27.1988f
C102 m4_3984_2028# avss 1.32738f
C103 m4_4128_1320# avdd 1.36255f
C104 m4_2016_1320# avss 2.45158f
C105 bpb znm 8.04743f
C106 m4_1488_2028# avdd 2.40167f
C107 m4_n624_2028# avss 1.32738f
C108 m4_n480_1320# avdd 1.36255f
C109 ynp znp 10.0172f
C110 m4_3888_2028# avss 1.32738f
C111 m4_4032_1320# avdd 1.35883f
C112 m4_1920_1320# avss 2.30021f
C113 m4_1392_2028# avdd 2.49988f
C114 m4_n720_2028# avss 1.32738f
C115 m4_n576_1320# avdd 1.36255f
C116 m4_3792_2028# avss 1.32738f
C117 m4_3936_1320# avdd 1.35883f
C118 m4_1824_1320# avss 2.26351f
C119 bna a_2892_1344# 1.62398f
C120 m4_1296_2028# avdd 2.55896f
C121 m4_n816_2028# avss 1.32738f
C122 m4_n672_1320# avdd 1.36255f
C123 m4_3696_2028# avss 1.32738f
C124 m4_3840_1320# avdd 1.35883f
C125 m4_1728_1320# avss 2.25906f
C126 avdd o 30.9381f
C127 avss znm 32.1178f
C128 en zpm 2.06895f
C129 enb bpa_ 1.44426f
C130 ynp xp1 2.75095f
C131 znp a_n840_1339# 8.68006f
C132 m4_1200_2028# avdd 2.79126f
C133 m4_n912_2028# avss 1.32738f
C134 m4_n768_1320# avdd 1.36255f
C135 m4_3600_2028# avss 1.32738f
C136 m4_3744_1320# avdd 1.35883f
C137 m4_1632_1320# avss 2.25906f
C138 m4_1104_2028# avdd 2.70594f
C139 m4_n1008_2028# avss 1.32738f
C140 m4_n864_1320# avdd 1.36255f
C141 m4_3504_2028# avss 1.32738f
C142 m4_3648_1320# avdd 1.36255f
C143 m4_1536_1320# avss 2.25906f
C144 bpa xp1 1.48234f
C145 ypp avss 1.81421f
C146 znp avdd 4.99534f
C147 m4_1008_2028# avdd 2.70594f
C148 m4_n1104_2028# avss 1.32738f
C149 m4_n960_1320# avdd 1.36255f
C150 ypm inp 3.30344f
C151 m4_3408_2028# avss 1.32738f
C152 m4_3552_1320# avdd 1.36255f
C153 bpb a_2220_2052# 1.13629f
C154 m4_1440_1320# avss 2.26351f
C155 xp0 ynm 2.75095f
C156 xn inp 3.66829f
C157 a_n840_1339# bna_ 15.3766f
C158 a_2124_2052# avdd 1.28586f
C159 en o 1.16256f
C160 bpb bpa_ 42.3645f
C161 m4_912_2028# avdd 2.79126f
C162 m4_n1200_2028# avss 1.32738f
C163 m4_n1056_1320# avdd 1.36255f
C164 m4_3312_2028# avss 1.32738f
C165 m4_3456_1320# avdd 1.36255f
C166 m4_1344_1320# avss 2.30021f
C167 enb bna 2.29499f
C168 m4_816_2028# avdd 2.79126f
C169 m4_n1296_2028# avss 1.32738f
C170 m4_n1152_1320# avdd 1.36255f
C171 m4_3216_2028# avss 1.32738f
C172 a_2892_1344# avss 4.17216f
C173 xp1 avdd 4.24444f
C174 m4_3360_1320# avdd 1.36255f
C175 m4_1248_1320# avss 2.45158f
C176 ypp inm 4.48782f
C177 m4_720_2028# avdd 2.70594f
C178 m4_n1392_2028# avss 1.32738f
C179 m4_n1248_1320# avdd 1.36353f
C180 m4_3120_2028# avss 1.32738f
C181 m4_3264_1320# avdd 1.36255f
C182 m4_1152_1320# avss 2.29726f
C183 m4_624_2028# avdd 2.70594f
C184 inp o 5.84491f
C185 zpm znm 15.9761f
C186 m4_n1344_1320# avdd 1.39712f
C187 m4_3024_2028# avss 1.32738f
C188 m4_3168_1320# avdd 1.36255f
C189 m4_1056_1320# avss 2.26796f
C190 bpb bna 1.42587f
C191 ynp avdd 4.8071f
C192 m4_528_2028# avdd 2.79126f
C193 m4_n1440_1320# avdd 1.46772f
C194 m4_2928_2028# avss 1.32738f
C195 m4_3072_1320# avdd 1.36255f
C196 m4_960_1320# avss 2.29726f
C197 ypp ypm 1.15122f
C198 bna_ en 1.4299f
C199 ypp xn 1.10649f
C200 m4_432_2028# avdd 2.77843f
C201 m4_4944_2028# avdd 3.21567f
C202 m4_2832_2028# avss 1.32738f
C203 bpa zpp 1.67045f
C204 m4_2976_1320# avdd 1.36255f
C205 m4_864_1320# avss 2.45158f
C206 bpa avdd 53.0016f
C207 enb avss 33.1496f
C208 zpp a_n840_1339# 4.8916f
C209 m4_336_2028# avdd 2.73404f
C210 m4_4848_2028# avdd 3.04803f
C211 m4_2736_2028# avss 1.32738f
C212 m4_2880_1320# avdd 1.36255f
C213 znp a_2556_2052# 1.6227f
C214 m4_768_1320# avss 2.29726f
C215 znm o 39.9977f
C216 bna avss 61.3243f
C217 a_n840_1339# avdd 1.08932f
C218 m4_240_2028# avdd 2.73404f
C219 m4_4752_2028# avdd 3.04896f
C220 m4_2640_2028# avss 1.32738f
C221 xp0 inm 1.56839f
C222 ynm avss 24.4002f
C223 m4_2784_1320# avdd 1.36255f
C224 znp a_2460_2052# 1.6227f
C225 m4_672_1320# avss 2.3156f
C226 xp1 inp 1.56737f
C227 m4_144_2028# avdd 2.77843f
C228 zpp avdd 72.2519f
C229 m4_4656_2028# avdd 3.04896f
C230 m4_2544_2028# avss 1.32738f
C231 m4_2688_1320# avdd 1.36255f
C232 m4_576_1320# avss 2.4009f
C233 znp znm 5.96661f
C234 bpa en 2.21044f
C235 m4_48_2028# avdd 2.70702f
C236 bpb avss 2.1819f
C237 a_120_2047# avdd 13.5348f
C238 m4_4560_2028# avdd 3.04896f
C239 m4_2448_2028# avss 1.32738f
C240 m4_2592_1320# avdd 1.36255f
C241 m4_480_1320# avss 2.69407f
C242 m4_4992_1320# avss 2.20004f
C243 m4_n48_2028# avdd 2.5765f
C244 m4_4464_2028# avdd 3.04896f
C245 m4_2352_2028# avss 1.32738f
C246 m4_2496_1320# avdd 1.36255f
C247 m4_384_1320# avss 2.5895f
C248 m4_4896_1320# avss 3.16713f
C249 m4_n144_2028# avdd 2.57507f
C250 m4_4368_2028# avdd 2.73117f
C251 m4_2256_2028# avss 1.32738f
C252 m4_2400_1320# avdd 1.36255f
C253 zpp en 6.20059f
C254 m4_288_1320# avss 2.55359f
C255 m4_4800_1320# avss 3.16643f
C256 avdd en 40.567f
C257 m4_n240_2028# avdd 2.57507f
C258 m4_4272_2028# avdd 2.59708f
C259 m4_2160_2028# avss 1.32738f
C260 m4_2304_1320# avdd 1.36255f
C261 m4_192_1320# avss 2.59065f
C262 m4_4704_1320# avss 3.16643f
C263 bna xn 1.76544f
C264 m4_n336_2028# avdd 2.5765f
C265 m4_4176_2028# avdd 2.56367f
C266 m4_2064_2028# avss 1.32738f
C267 m4_2208_1320# avdd 1.36255f
C268 m4_96_1320# avss 2.81787f
C269 m4_4608_1320# avss 3.16643f
C270 m4_n432_2028# avdd 2.64853f
C271 m4_4080_2028# avdd 2.57028f
C272 m4_1968_2028# avss 1.32738f
C273 m4_2112_1320# avdd 1.36255f
C274 znp a_2220_2052# 1.6227f
C275 m4_0_1320# avss 2.6372f
C276 m4_4512_1320# avss 3.16643f
C277 m4_n528_2028# avdd 2.64853f
C278 avdd inp 12.1971f
C279 avss inm 10.0246f
C280 m4_3984_2028# avdd 2.58514f
C281 m4_1872_2028# avss 1.32738f
C282 m4_2016_1320# avdd 1.36255f
C283 m4_n96_1320# avss 2.55342f
C284 m4_4416_1320# avss 3.07548f
C285 bpb zpm 7.74006f
C286 a_2556_2052# avdd 1.28624f
C287 m4_n624_2028# avdd 2.5765f
C288 m4_3888_2028# avdd 2.75516f
C289 m4_1776_2028# avss 1.32738f
C290 m4_1920_1320# avdd 1.36255f
C291 m4_n192_1320# avss 2.55342f
C292 a_n840_1339# znm 7.59793f
C293 m4_4320_1320# avss 2.66098f
C294 a_2460_2052# avdd 1.24532f
C295 m4_n720_2028# avdd 2.57507f
C296 m4_3792_2028# avdd 2.58514f
C297 ynm o 1.23196f
C298 m4_1680_2028# avss 1.32738f
C299 m4_1824_1320# avdd 1.36255f
C300 m4_n288_1320# avss 2.55342f
C301 m4_4224_1320# avss 2.58884f
C302 ypm avss 1.86716f
C303 enb znp 7.40918f
C304 m4_n816_2028# avdd 2.57507f
C305 xn avss 4.57768f
C306 m4_3696_2028# avdd 2.57028f
C307 m4_1584_2028# avss 1.32738f
C308 m4_1728_1320# avdd 1.36255f
C309 m4_n384_1320# avss 2.55342f
C310 avss zpm 7.78478f
C311 avdd znm 14.1062f
C312 m4_4128_1320# avss 2.57254f
C313 znp bna 2.50436f
C314 m4_n912_2028# avdd 2.5765f
C315 m4_3600_2028# avdd 2.56367f
C316 m4_1488_2028# avss 1.32738f
C317 m4_1632_1320# avdd 1.36255f
C318 m4_n480_1320# avss 2.55342f
C319 ynm znp 8.54865f
C320 m4_4032_1320# avss 2.5479f
C321 zpp ypp 22.214f
C322 m4_n1008_2028# avdd 2.64853f
C323 m4_3504_2028# avdd 2.57269f
C324 m4_1392_2028# avss 1.32738f
C325 m4_1536_1320# avdd 1.36255f
C326 m4_n576_1320# avss 2.55342f
C327 ypp avdd 21.2676f
C328 m4_3936_1320# avss 2.54379f
C329 m4_n1104_2028# avdd 2.46693f
C330 m4_3408_2028# avdd 2.64118f
C331 a_n840_1339# a_2892_1344# 4.432f
C332 bpb znp 5.59f
C333 m4_1296_2028# avss 1.32738f
C334 m4_1440_1320# avdd 1.36255f
C335 xp0 ynp 2.75095f
C336 xn inm 3.66741f
C337 bna bna_ 2.95474f
C338 m4_n672_1320# avss 2.55342f
C339 m4_3840_1320# avss 2.54379f
C340 avss o 18.6295f
C341 inm zpm 1.13442f
C342 bpa bpa_ 4.50883f
C343 ynm xp1 2.75095f
C344 m4_n1200_2028# avdd 2.51519f
C345 m4_3312_2028# avdd 2.57787f
C346 bpb a_2124_2052# 1.13629f
C347 m4_1200_2028# avss 1.32738f
C348 m4_1344_1320# avdd 1.36255f
C349 m4_n768_1320# avss 2.55342f
C350 m4_3744_1320# avss 2.5479f
C351 zpp a_2892_1344# 2.53545f
C352 m4_n1296_2028# avdd 2.59843f
C353 bpa xp0 1.48234f
C354 m4_3216_2028# avdd 2.42487f
C355 m4_1104_2028# avss 1.32738f
C356 m4_1248_1320# avdd 1.36255f
C357 m4_n864_1320# avss 2.55342f
C358 m4_3648_1320# avss 2.54863f
C359 a_2220_2052# avdd 1.24532f
C360 znp avss 67.7844f
C361 m4_n1392_2028# avdd 3.20841f
C362 ypm xn 1.10649f
C363 m4_3120_2028# avdd 2.44343f
C364 m4_1008_2028# avss 1.32738f
C365 m4_1152_1320# avdd 1.36255f
C366 m4_n960_1320# avss 2.58567f
C367 ypm zpm 9.05863f
C368 m4_3552_1320# avss 2.54897f
C369 ynp ynm 1.52753f
C370 bpa_ avdd 20.9481f
C371 enb bpa 1.4995f
C372 inp znm 1.70255f
C373 inm o 6.9664f
C374 m4_3024_2028# avdd 2.61439f
C375 m4_912_2028# avss 1.32738f
C376 m4_1056_1320# avdd 1.36255f
C377 m4_n1056_1320# avss 2.69833f
C378 m4_3456_1320# avss 2.58272f
C379 enb a_n840_1339# 1.79431f
C380 xp0 avdd 4.24444f
C381 m4_2928_2028# avdd 2.44343f
C382 m4_816_2028# avss 1.32738f
C383 m4_960_1320# avdd 1.36255f
C384 m4_n1152_1320# avss 2.41659f
C385 bna a_n840_1339# 10.2662f
C386 m4_3360_1320# avss 2.70599f
C387 bna_ avss 13.8816f
C388 m4_2832_2028# avdd 2.42487f
C389 m4_720_2028# avss 1.32738f
C390 m4_864_1320# avdd 1.36255f
C391 m4_n1248_1320# avss 2.71444f
C392 m4_3264_1320# avss 2.44294f
C393 enb avdd 4.52372f
C394 bpa_ en 1.33939f
C395 m4_2736_2028# avdd 2.51879f
C396 bpa bpb 9.52617f
C397 o vsub 36.154f
C398 avss vsub 69.52782f
C399 avdd vsub 0.92914p
C400 a_1716_1344# vsub 5.6768f
C401 a_n1308_1344# vsub 1.15634f
C402 a_4740_1512# vsub 6.8825f
C403 a_3828_1512# vsub 1.05716f
C404 a_2244_1512# vsub 2.89337f
C405 xn vsub 6.65287f
C406 a_n972_1512# vsub 1.00686f
C407 a_n996_1512# vsub 1.00686f
C408 bna_ vsub 1.40194f
C409 a_2964_2052# vsub 2.52753f
C410 a_2460_2052# vsub 1.66712f
C411 ypm vsub 2.121f
C412 ypp vsub 4.14878f
C413 xp1 vsub 6.51058f
C414 ynm vsub 4.4622f
C415 ynp vsub 14.20637f
.ends
