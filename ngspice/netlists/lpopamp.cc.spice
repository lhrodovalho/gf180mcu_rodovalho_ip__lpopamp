* NGSPICE file created from lpopamp.ext - technology: gf180mcuC

.subckt lpopamp_slice inm inp o avdd avss en vsub zpm znm bnb w_22_22#
X0 ypp inm a_3204_276# avss nfet_06v0 ad=1.98p pd=7.2u as=1.98p ps=7.2u w=6.6u l=0.6u
X1 a_3516_276# znp a_3492_276# avss nfet_06v0 ad=1.98p pd=7.2u as=1.98p ps=7.2u w=6.6u l=0.6u
X2 a_3036_816# zpp a_3012_816# avdd pfet_06v0 ad=1.98p pd=7.2u as=1.98p ps=7.2u w=6.6u l=0.6u
X3 a_2052_276# znp a_2028_276# avss nfet_06v0 ad=1.98p pd=7.2u as=1.98p ps=7.2u w=6.6u l=0.6u
X4 a_3324_816# zpp a_3300_816# avdd pfet_06v0 ad=1.98p pd=7.2u as=1.98p ps=7.2u w=6.6u l=0.6u
X5 a_5508_108# bnb zpm avss nfet_06v0 ad=1.98p pd=7.2u as=1.98p ps=7.2u w=6.6u l=0.6u
X6 a_5796_108# znp a_5772_108# avss nfet_06v0 ad=1.98p pd=7.2u as=1.98p ps=7.2u w=6.6u l=0.6u
X7 a_3564_816# bpb znp avdd pfet_06v0 ad=1.98p pd=7.2u as=1.98p ps=7.2u w=6.6u l=0.6u
X8 zpm zpp ypm avdd pfet_06v0 ad=1.98p pd=7.2u as=1.98p ps=7.2u w=6.6u l=0.6u
X9 a_1236_108# bnb bnb avss nfet_06v0 ad=1.98p pd=7.2u as=1.98p ps=7.2u w=6.6u l=0.6u
X10 a_1524_108# bna a_1500_108# avss nfet_06v0 ad=1.98p pd=7.2u as=1.98p ps=7.2u w=6.6u l=0.6u
X11 a_3996_816# bpb znp avdd pfet_06v0 ad=1.98p pd=7.2u as=1.98p ps=7.2u w=6.6u l=0.6u
X12 ypp zpp zpp avdd pfet_06v0 ad=1.98p pd=7.2u as=1.98p ps=7.2u w=6.6u l=0.6u
X13 a_1812_108# bna a_1788_108# avss nfet_06v0 ad=1.98p pd=7.2u as=1.98p ps=7.2u w=6.6u l=0.6u
X14 a_3420_276# bna a_3396_276# avss nfet_06v0 ad=1.98p pd=7.2u as=1.98p ps=7.2u w=6.6u l=0.6u
X15 a_3228_816# zpp a_3204_816# avdd pfet_06v0 ad=1.98p pd=7.2u as=1.98p ps=7.2u w=6.6u l=0.6u
X16 bpb bpb bpa_ avdd pfet_06v0 ad=1.98p pd=7.2u as=1.98p ps=7.2u w=6.6u l=0.6u
X17 a_3516_816# bpa a_3492_816# avdd pfet_06v0 ad=1.98p pd=7.2u as=1.98p ps=7.2u w=6.6u l=0.6u
X18 a_2244_276# znp a_2220_276# avss nfet_06v0 ad=1.98p pd=7.2u as=1.98p ps=7.2u w=6.6u l=0.6u
X19 a_2532_276# znp ynm avss nfet_06v0 ad=1.98p pd=7.2u as=1.98p ps=7.2u w=6.6u l=0.6u
X20 a_5700_108# znp ynm avss nfet_06v0 ad=1.98p pd=7.2u as=1.98p ps=7.2u w=6.6u l=0.6u
X21 ynp inm xp0 avdd pfet_06v0 ad=1.98p pd=7.2u as=1.98p ps=7.2u w=6.6u l=0.6u
X22 a_5988_108# znm avss avss nfet_06v0 ad=1.98p pd=7.2u as=1.98p ps=7.2u w=6.6u l=0.6u
X23 a_1428_108# bna a_1404_108# avss nfet_06v0 ad=1.98p pd=7.2u as=1.98p ps=7.2u w=6.6u l=0.6u
X24 a_1140_108# bnb bnb avss nfet_06v0 ad=1.98p pd=7.2u as=1.98p ps=7.2u w=6.6u l=0.6u
X25 a_1716_108# bna a_1692_108# avss nfet_06v0 ad=1.98p pd=7.2u as=1.98p ps=7.2u w=6.6u l=0.6u
X26 ypp zpp a_4212_984# avdd pfet_06v0 ad=1.98p pd=7.2u as=1.98p ps=7.2u w=6.6u l=0.6u
X27 a_4524_984# zpp a_4500_984# avdd pfet_06v0 ad=1.98p pd=7.2u as=1.98p ps=7.2u w=6.6u l=0.6u
X28 avdd zpp a_4788_984# avdd pfet_06v0 ad=1.98p pd=7.2u as=1.98p ps=7.2u w=6.6u l=0.6u
X29 bpb bpb bpa_ avdd pfet_06v0 ad=1.98p pd=7.2u as=1.98p ps=7.2u w=6.6u l=0.6u
X30 a_2148_276# znp ynp avss nfet_06v0 ad=1.98p pd=7.2u as=1.98p ps=7.2u w=6.6u l=0.6u
X31 a_996_984# bpa avdd avdd pfet_06v0 ad=1.98p pd=7.2u as=1.98p ps=7.2u w=6.6u l=0.6u
X32 a_3420_816# zpp a_3396_816# avdd pfet_06v0 ad=1.98p pd=7.2u as=1.98p ps=7.2u w=6.6u l=0.6u
X33 a_2436_276# znp a_2412_276# avss nfet_06v0 ad=1.98p pd=7.2u as=1.98p ps=7.2u w=6.6u l=0.6u
X34 a_2724_276# bna avss avss nfet_06v0 ad=1.98p pd=7.2u as=1.98p ps=7.2u w=6.6u l=0.6u
X35 a_2244_816# bpa xp0 avdd pfet_06v0 ad=1.98p pd=7.2u as=1.98p ps=7.2u w=6.6u l=0.6u
X36 ynp inm xp1 avdd pfet_06v0 ad=1.98p pd=7.2u as=1.98p ps=7.2u w=6.6u l=0.6u
X37 ynm znp a_4980_108# avss nfet_06v0 ad=1.98p pd=7.2u as=1.98p ps=7.2u w=6.6u l=0.6u
X38 a_1620_108# bna a_1596_108# avss nfet_06v0 ad=1.98p pd=7.2u as=1.98p ps=7.2u w=6.6u l=0.6u
X39 avdd bpa a_4116_984# avdd pfet_06v0 ad=1.98p pd=7.2u as=1.98p ps=7.2u w=6.6u l=0.6u
X40 a_4428_984# zpp a_4404_984# avdd pfet_06v0 ad=1.98p pd=7.2u as=1.98p ps=7.2u w=6.6u l=0.6u
X41 ypp zpp zpp avdd pfet_06v0 ad=1.98p pd=7.2u as=1.98p ps=7.2u w=6.6u l=0.6u
X42 a_3252_984# zpp a_3228_984# avdd pfet_06v0 ad=1.98p pd=7.2u as=1.98p ps=7.2u w=6.6u l=0.6u
X43 a_2340_276# znp avss avss nfet_06v0 ad=1.98p pd=7.2u as=1.98p ps=7.2u w=6.6u l=0.6u
X44 a_900_984# bpa bpa_ avdd pfet_06v0 ad=1.98p pd=7.2u as=1.98p ps=7.2u w=6.6u l=0.6u
X45 a_2628_276# znp a_2604_276# avss nfet_06v0 ad=1.98p pd=7.2u as=1.98p ps=7.2u w=6.6u l=0.6u
X46 ynm inp xp0 avdd pfet_06v0 ad=1.98p pd=7.2u as=1.98p ps=7.2u w=6.6u l=0.6u
X47 bna_ bnb a_1140_276# avss nfet_06v0 ad=1.98p pd=7.2u as=1.98p ps=7.2u w=6.6u l=0.6u
X48 a_2916_276# inm xn avss nfet_06v0 ad=1.98p pd=7.2u as=1.98p ps=7.2u w=6.6u l=0.6u
X49 ynm inp xp1 avdd pfet_06v0 ad=1.98p pd=7.2u as=1.98p ps=7.2u w=6.6u l=0.6u
X50 a_1452_276# bna a_1428_276# avss nfet_06v0 ad=1.98p pd=7.2u as=1.98p ps=7.2u w=6.6u l=0.6u
X51 a_4908_108# znp a_4884_108# avss nfet_06v0 ad=1.98p pd=7.2u as=1.98p ps=7.2u w=6.6u l=0.6u
X52 a_2724_816# zpp avdd avdd pfet_06v0 ad=1.98p pd=7.2u as=1.98p ps=7.2u w=6.6u l=0.6u
X53 ypp zpp zpp avdd pfet_06v0 ad=1.98p pd=7.2u as=1.98p ps=7.2u w=6.6u l=0.6u
X54 o znm a_5988_276# avss nfet_06v0 ad=1.98p pd=7.2u as=1.98p ps=7.2u w=6.6u l=0.6u
X55 a_3156_984# zpp a_3132_984# avdd pfet_06v0 ad=1.98p pd=7.2u as=1.98p ps=7.2u w=6.6u l=0.6u
X56 a_3444_984# zpp a_3420_984# avdd pfet_06v0 ad=1.98p pd=7.2u as=1.98p ps=7.2u w=6.6u l=0.6u
X57 a_3732_984# bpa a_3660_816# avdd pfet_06v0 ad=1.98p pd=7.2u as=1.98p ps=7.2u w=6.6u l=0.6u
X58 a_2820_276# bna a_2796_276# avss nfet_06v0 ad=1.98p pd=7.2u as=1.98p ps=7.2u w=6.6u l=0.6u
X59 a_2340_816# bpa avdd avdd pfet_06v0 ad=1.98p pd=7.2u as=1.98p ps=7.2u w=6.6u l=0.6u
X60 bna_ bnb a_1044_276# avss nfet_06v0 ad=1.98p pd=7.2u as=1.98p ps=7.2u w=6.6u l=0.6u
X61 a_2628_816# bpa xp1 avdd pfet_06v0 ad=1.98p pd=7.2u as=1.98p ps=7.2u w=6.6u l=0.6u
X62 bna_ bnb a_1332_276# avss nfet_06v0 ad=1.98p pd=7.2u as=1.98p ps=7.2u w=6.6u l=0.6u
X63 a_1644_276# bna a_1620_276# avss nfet_06v0 ad=1.98p pd=7.2u as=1.98p ps=7.2u w=6.6u l=0.6u
X64 bpa_ bpb bpb avdd pfet_06v0 ad=1.98p pd=7.2u as=1.98p ps=7.2u w=6.6u l=0.6u
X65 a_2916_816# zpp avdd avdd pfet_06v0 ad=1.98p pd=7.2u as=1.98p ps=7.2u w=6.6u l=0.6u
X66 avss bna a_1908_276# avss nfet_06v0 ad=1.98p pd=7.2u as=1.98p ps=7.2u w=6.6u l=0.6u
X67 bpa_ bpb bpb avdd pfet_06v0 ad=1.98p pd=7.2u as=1.98p ps=7.2u w=6.6u l=0.6u
X68 avss en a_180_108# avss nfet_06v0 ad=1.98p pd=7.2u as=1.98p ps=7.2u w=6.6u l=0.6u
X69 a_3060_984# zpp a_3036_984# avdd pfet_06v0 ad=1.98p pd=7.2u as=1.98p ps=7.2u w=6.6u l=0.6u
X70 a_492_108# bna a_468_108# avss nfet_06v0 ad=1.98p pd=7.2u as=1.98p ps=7.2u w=6.6u l=0.6u
X71 a_3348_984# zpp a_3324_984# avdd pfet_06v0 ad=1.98p pd=7.2u as=1.98p ps=7.2u w=6.6u l=0.6u
X72 znp bpb a_3564_816# avdd pfet_06v0 ad=1.98p pd=7.2u as=1.98p ps=7.2u w=6.6u l=0.6u
X73 znp bpb a_3900_816# avdd pfet_06v0 ad=1.98p pd=7.2u as=1.98p ps=7.2u w=6.6u l=0.6u
X74 avdd zpm o avdd pfet_06v0 ad=1.98p pd=7.2u as=1.98p ps=7.2u w=6.6u l=0.6u
X75 xp0 inp ynm avdd pfet_06v0 ad=1.98p pd=7.2u as=1.98p ps=7.2u w=6.6u l=0.6u
X76 bna_ bnb a_1236_276# avss nfet_06v0 ad=1.98p pd=7.2u as=1.98p ps=7.2u w=6.6u l=0.6u
X77 a_2820_816# zpp ypp avdd pfet_06v0 ad=1.98p pd=7.2u as=1.98p ps=7.2u w=6.6u l=0.6u
X78 avss bna a_1524_276# avss nfet_06v0 ad=1.98p pd=7.2u as=1.98p ps=7.2u w=6.6u l=0.6u
X79 a_4212_108# bna a_4188_108# avss nfet_06v0 ad=1.98p pd=7.2u as=1.98p ps=7.2u w=6.6u l=0.6u
X80 bpa_ bpa a_1044_816# avdd pfet_06v0 ad=1.98p pd=7.2u as=1.98p ps=7.2u w=6.6u l=0.6u
X81 bpa_ bpb bpb avdd pfet_06v0 ad=1.98p pd=7.2u as=1.98p ps=7.2u w=6.6u l=0.6u
X82 a_1836_276# bna a_1812_276# avss nfet_06v0 ad=1.98p pd=7.2u as=1.98p ps=7.2u w=6.6u l=0.6u
X83 a_1644_816# a_1560_811# a_1560_811# avdd pfet_06v0 ad=1.98p pd=7.2u as=1.98p ps=7.2u w=6.6u l=0.6u
X84 avss enb a_372_108# avss nfet_06v0 ad=1.98p pd=7.2u as=1.98p ps=7.2u w=6.6u l=0.6u
X85 avdd a_1560_811# a_1560_811# avdd pfet_06v0 ad=1.98p pd=7.2u as=1.98p ps=7.2u w=6.6u l=0.6u
X86 bna_ bnb a_660_108# avss nfet_06v0 ad=1.98p pd=7.2u as=1.98p ps=7.2u w=6.6u l=0.6u
X87 a_3540_984# bpa a_3516_984# avdd pfet_06v0 ad=1.98p pd=7.2u as=1.98p ps=7.2u w=6.6u l=0.6u
X88 bna_ bnb a_948_108# avss nfet_06v0 ad=1.98p pd=7.2u as=1.98p ps=7.2u w=6.6u l=0.6u
X89 xp0 inm ynp avdd pfet_06v0 ad=1.98p pd=7.2u as=1.98p ps=7.2u w=6.6u l=0.6u
X90 a_3828_984# bpa avdd avdd pfet_06v0 ad=1.98p pd=7.2u as=1.98p ps=7.2u w=6.6u l=0.6u
X91 a_2364_984# bpa a_2340_984# avdd pfet_06v0 ad=1.98p pd=7.2u as=1.98p ps=7.2u w=6.6u l=0.6u
X92 a_2652_984# bpa a_2628_984# avdd pfet_06v0 ad=1.98p pd=7.2u as=1.98p ps=7.2u w=6.6u l=0.6u
X93 bpb bna a_1716_276# avss nfet_06v0 ad=1.98p pd=7.2u as=1.98p ps=7.2u w=6.6u l=0.6u
X94 a_4116_108# znp a_4092_108# avss nfet_06v0 ad=1.98p pd=7.2u as=1.98p ps=7.2u w=6.6u l=0.6u
X95 bpa_ bpb bpb avdd pfet_06v0 ad=1.98p pd=7.2u as=1.98p ps=7.2u w=6.6u l=0.6u
X96 avdd bpa a_1524_816# avdd pfet_06v0 ad=1.98p pd=7.2u as=1.98p ps=7.2u w=6.6u l=0.6u
X97 a_1836_816# a_1560_811# a_1560_811# avdd pfet_06v0 ad=1.98p pd=7.2u as=1.98p ps=7.2u w=6.6u l=0.6u
X98 bna_ bna a_564_108# avss nfet_06v0 ad=1.98p pd=7.2u as=1.98p ps=7.2u w=6.6u l=0.6u
X99 bna_ en a_276_108# avss nfet_06v0 ad=1.98p pd=7.2u as=1.98p ps=7.2u w=6.6u l=0.6u
X100 bna_ bnb a_852_108# avss nfet_06v0 ad=1.98p pd=7.2u as=1.98p ps=7.2u w=6.6u l=0.6u
X101 a_5412_276# bnb zpm avss nfet_06v0 ad=1.98p pd=7.2u as=1.98p ps=7.2u w=6.6u l=0.6u
X102 a_5124_276# znp ynm avss nfet_06v0 ad=1.98p pd=7.2u as=1.98p ps=7.2u w=6.6u l=0.6u
X103 a_2268_984# bpa a_2244_984# avdd pfet_06v0 ad=1.98p pd=7.2u as=1.98p ps=7.2u w=6.6u l=0.6u
X104 xp1 inm ynp avdd pfet_06v0 ad=1.98p pd=7.2u as=1.98p ps=7.2u w=6.6u l=0.6u
X105 bpb bpb bpa_ avdd pfet_06v0 ad=1.98p pd=7.2u as=1.98p ps=7.2u w=6.6u l=0.6u
X106 a_2844_984# zpp a_2820_984# avdd pfet_06v0 ad=1.98p pd=7.2u as=1.98p ps=7.2u w=6.6u l=0.6u
X107 a_4020_108# znp a_3996_108# avss nfet_06v0 ad=1.98p pd=7.2u as=1.98p ps=7.2u w=6.6u l=0.6u
X108 a_1740_816# a_1560_811# a_1560_811# avdd pfet_06v0 ad=1.98p pd=7.2u as=1.98p ps=7.2u w=6.6u l=0.6u
X109 ypm inp a_3108_108# avss nfet_06v0 ad=1.98p pd=7.2u as=1.98p ps=7.2u w=6.6u l=0.6u
X110 bna_ bnb a_756_108# avss nfet_06v0 ad=1.98p pd=7.2u as=1.98p ps=7.2u w=6.6u l=0.6u
X111 a_5028_276# znp ynm avss nfet_06v0 ad=1.98p pd=7.2u as=1.98p ps=7.2u w=6.6u l=0.6u
X112 a_5316_276# bnb zpm avss nfet_06v0 ad=1.98p pd=7.2u as=1.98p ps=7.2u w=6.6u l=0.6u
X113 xp1 inp ynm avdd pfet_06v0 ad=1.98p pd=7.2u as=1.98p ps=7.2u w=6.6u l=0.6u
X114 zpm bpb znm avdd pfet_06v0 ad=1.98p pd=7.2u as=1.98p ps=7.2u w=6.6u l=0.6u
X115 a_2748_984# zpp a_2724_984# avdd pfet_06v0 ad=1.98p pd=7.2u as=1.98p ps=7.2u w=6.6u l=0.6u
X116 a_5412_816# zpp a_5388_816# avdd pfet_06v0 ad=1.98p pd=7.2u as=1.98p ps=7.2u w=6.6u l=0.6u
X117 bpb bpb bpa_ avdd pfet_06v0 ad=1.98p pd=7.2u as=1.98p ps=7.2u w=6.6u l=0.6u
X118 a_1560_811# a_1560_811# avdd avdd pfet_06v0 ad=1.98p pd=7.2u as=1.98p ps=7.2u w=6.6u l=0.6u
X119 a_3324_108# bna a_3300_108# avss nfet_06v0 ad=1.98p pd=7.2u as=1.98p ps=7.2u w=6.6u l=0.6u
X120 ypm inp a_3012_108# avss nfet_06v0 ad=1.98p pd=7.2u as=1.98p ps=7.2u w=6.6u l=0.6u
X121 a_3612_108# znp a_3588_108# avss nfet_06v0 ad=1.98p pd=7.2u as=1.98p ps=7.2u w=6.6u l=0.6u
X122 o zpm avdd avdd pfet_06v0 ad=1.98p pd=7.2u as=1.98p ps=7.2u w=6.6u l=0.6u
X123 a_5220_276# bnb zpm avss nfet_06v0 ad=1.98p pd=7.2u as=1.98p ps=7.2u w=6.6u l=0.6u
X124 zpm bpb znm avdd pfet_06v0 ad=1.98p pd=7.2u as=1.98p ps=7.2u w=6.6u l=0.6u
X125 a_4044_276# znp a_4020_276# avss nfet_06v0 ad=1.98p pd=7.2u as=1.98p ps=7.2u w=6.6u l=0.6u
X126 bpb bpb bpa_ avdd pfet_06v0 ad=1.98p pd=7.2u as=1.98p ps=7.2u w=6.6u l=0.6u
X127 a_2940_984# zpp a_2916_984# avdd pfet_06v0 ad=1.98p pd=7.2u as=1.98p ps=7.2u w=6.6u l=0.6u
X128 a_5316_816# zpp a_5292_816# avdd pfet_06v0 ad=1.98p pd=7.2u as=1.98p ps=7.2u w=6.6u l=0.6u
X129 a_4332_108# bna a_4308_276# avss nfet_06v0 ad=1.98p pd=7.2u as=1.98p ps=7.2u w=6.6u l=0.6u
X130 a_1476_984# bpa bpa_ avdd pfet_06v0 ad=1.98p pd=7.2u as=1.98p ps=7.2u w=6.6u l=0.6u
X131 a_1560_811# a_1560_811# a_1740_984# avdd pfet_06v0 ad=1.98p pd=7.2u as=1.98p ps=7.2u w=6.6u l=0.6u
X132 a_804_276# bnb bna_ avss nfet_06v0 ad=1.98p pd=7.2u as=1.98p ps=7.2u w=6.6u l=0.6u
X133 ypp inm a_3204_108# avss nfet_06v0 ad=1.98p pd=7.2u as=1.98p ps=7.2u w=6.6u l=0.6u
X134 a_3516_108# znp a_3492_108# avss nfet_06v0 ad=1.98p pd=7.2u as=1.98p ps=7.2u w=6.6u l=0.6u
X135 o zpm avdd avdd pfet_06v0 ad=1.98p pd=7.2u as=1.98p ps=7.2u w=6.6u l=0.6u
X136 a_6324_984# en zpm avdd pfet_06v0 ad=1.98p pd=7.2u as=1.98p ps=7.2u w=6.6u l=0.6u
X137 a_2052_108# znp a_2028_108# avss nfet_06v0 ad=1.98p pd=7.2u as=1.98p ps=7.2u w=6.6u l=0.6u
X138 zpm zpp ypm avdd pfet_06v0 ad=1.98p pd=7.2u as=1.98p ps=7.2u w=6.6u l=0.6u
X139 a_4236_276# bna a_4212_276# avss nfet_06v0 ad=1.98p pd=7.2u as=1.98p ps=7.2u w=6.6u l=0.6u
X140 bpb bpb bpa_ avdd pfet_06v0 ad=1.98p pd=7.2u as=1.98p ps=7.2u w=6.6u l=0.6u
X141 a_4332_108# bnb a_4500_276# avss nfet_06v0 ad=1.98p pd=7.2u as=1.98p ps=7.2u w=6.6u l=0.6u
X142 a_1560_811# a_1560_811# a_1644_984# avdd pfet_06v0 ad=1.98p pd=7.2u as=1.98p ps=7.2u w=6.6u l=0.6u
X143 a_3996_816# bpb znp avdd pfet_06v0 ad=1.98p pd=7.2u as=1.98p ps=7.2u w=6.6u l=0.6u
X144 avss bna a_4788_276# avss nfet_06v0 ad=1.98p pd=7.2u as=1.98p ps=7.2u w=6.6u l=0.6u
X145 a_1956_984# bpa avdd avdd pfet_06v0 ad=1.98p pd=7.2u as=1.98p ps=7.2u w=6.6u l=0.6u
X146 ypp zpp zpp avdd pfet_06v0 ad=1.98p pd=7.2u as=1.98p ps=7.2u w=6.6u l=0.6u
X147 a_708_276# bnb bna_ avss nfet_06v0 ad=1.98p pd=7.2u as=1.98p ps=7.2u w=6.6u l=0.6u
X148 a_3420_108# bna a_3396_108# avss nfet_06v0 ad=1.98p pd=7.2u as=1.98p ps=7.2u w=6.6u l=0.6u
X149 a_996_276# bnb bna_ avss nfet_06v0 ad=1.98p pd=7.2u as=1.98p ps=7.2u w=6.6u l=0.6u
X150 o zpm avdd avdd pfet_06v0 ad=1.98p pd=7.2u as=1.98p ps=7.2u w=6.6u l=0.6u
X151 bpb bpb bpa_ avdd pfet_06v0 ad=1.98p pd=7.2u as=1.98p ps=7.2u w=6.6u l=0.6u
X152 a_2244_108# znp a_2220_108# avss nfet_06v0 ad=1.98p pd=7.2u as=1.98p ps=7.2u w=6.6u l=0.6u
X153 a_2532_108# znp ynm avss nfet_06v0 ad=1.98p pd=7.2u as=1.98p ps=7.2u w=6.6u l=0.6u
X154 znm bpb zpm avdd pfet_06v0 ad=1.98p pd=7.2u as=1.98p ps=7.2u w=6.6u l=0.6u
X155 avss znp a_4116_276# avss nfet_06v0 ad=1.98p pd=7.2u as=1.98p ps=7.2u w=6.6u l=0.6u
X156 a_4716_276# bna a_4692_276# avss nfet_06v0 ad=1.98p pd=7.2u as=1.98p ps=7.2u w=6.6u l=0.6u
X157 a_4332_108# bnb a_4404_276# avss nfet_06v0 ad=1.98p pd=7.2u as=1.98p ps=7.2u w=6.6u l=0.6u
X158 a_1560_811# a_1560_811# a_1836_984# avdd pfet_06v0 ad=1.98p pd=7.2u as=1.98p ps=7.2u w=6.6u l=0.6u
X159 ypp zpp a_4212_816# avdd pfet_06v0 ad=1.98p pd=7.2u as=1.98p ps=7.2u w=6.6u l=0.6u
X160 a_4524_816# zpp a_4500_816# avdd pfet_06v0 ad=1.98p pd=7.2u as=1.98p ps=7.2u w=6.6u l=0.6u
X161 a_900_276# bnb bna_ avss nfet_06v0 ad=1.98p pd=7.2u as=1.98p ps=7.2u w=6.6u l=0.6u
X162 a_3252_276# inm ypp avss nfet_06v0 ad=1.98p pd=7.2u as=1.98p ps=7.2u w=6.6u l=0.6u
X163 avdd zpp a_4788_816# avdd pfet_06v0 ad=1.98p pd=7.2u as=1.98p ps=7.2u w=6.6u l=0.6u
X164 bpb bpb bpa_ avdd pfet_06v0 ad=1.98p pd=7.2u as=1.98p ps=7.2u w=6.6u l=0.6u
X165 a_2436_108# znp a_2412_108# avss nfet_06v0 ad=1.98p pd=7.2u as=1.98p ps=7.2u w=6.6u l=0.6u
X166 a_2148_108# znp ynp avss nfet_06v0 ad=1.98p pd=7.2u as=1.98p ps=7.2u w=6.6u l=0.6u
X167 a_996_816# bpa avdd avdd pfet_06v0 ad=1.98p pd=7.2u as=1.98p ps=7.2u w=6.6u l=0.6u
X168 a_2724_108# bna avss avss nfet_06v0 ad=1.98p pd=7.2u as=1.98p ps=7.2u w=6.6u l=0.6u
X169 ypm zpp zpm avdd pfet_06v0 ad=1.98p pd=7.2u as=1.98p ps=7.2u w=6.6u l=0.6u
X170 znm bpb zpm avdd pfet_06v0 ad=1.98p pd=7.2u as=1.98p ps=7.2u w=6.6u l=0.6u
X171 a_4332_108# bnb a_4596_276# avss nfet_06v0 ad=1.98p pd=7.2u as=1.98p ps=7.2u w=6.6u l=0.6u
X172 avdd bpa a_4116_816# avdd pfet_06v0 ad=1.98p pd=7.2u as=1.98p ps=7.2u w=6.6u l=0.6u
X173 a_3156_276# inp ypm avss nfet_06v0 ad=1.98p pd=7.2u as=1.98p ps=7.2u w=6.6u l=0.6u
X174 a_4428_816# zpp a_4404_816# avdd pfet_06v0 ad=1.98p pd=7.2u as=1.98p ps=7.2u w=6.6u l=0.6u
X175 ypp zpp zpp avdd pfet_06v0 ad=1.98p pd=7.2u as=1.98p ps=7.2u w=6.6u l=0.6u
X176 a_3444_276# bna a_3420_276# avss nfet_06v0 ad=1.98p pd=7.2u as=1.98p ps=7.2u w=6.6u l=0.6u
X177 a_3252_816# zpp a_3228_816# avdd pfet_06v0 ad=1.98p pd=7.2u as=1.98p ps=7.2u w=6.6u l=0.6u
X178 a_3732_276# znp znp avss nfet_06v0 ad=1.98p pd=7.2u as=1.98p ps=7.2u w=6.6u l=0.6u
X179 a_900_816# bpa bpa_ avdd pfet_06v0 ad=1.98p pd=7.2u as=1.98p ps=7.2u w=6.6u l=0.6u
X180 a_2340_108# znp avss avss nfet_06v0 ad=1.98p pd=7.2u as=1.98p ps=7.2u w=6.6u l=0.6u
X181 znm bpb zpm avdd pfet_06v0 ad=1.98p pd=7.2u as=1.98p ps=7.2u w=6.6u l=0.6u
X182 a_2916_108# inm xn avss nfet_06v0 ad=1.98p pd=7.2u as=1.98p ps=7.2u w=6.6u l=0.6u
X183 a_2628_108# znp a_2604_108# avss nfet_06v0 ad=1.98p pd=7.2u as=1.98p ps=7.2u w=6.6u l=0.6u
X184 ypm zpp a_5412_984# avdd pfet_06v0 ad=1.98p pd=7.2u as=1.98p ps=7.2u w=6.6u l=0.6u
X185 a_1452_108# bna a_1428_108# avss nfet_06v0 ad=1.98p pd=7.2u as=1.98p ps=7.2u w=6.6u l=0.6u
X186 bna_ bnb a_1140_108# avss nfet_06v0 ad=1.98p pd=7.2u as=1.98p ps=7.2u w=6.6u l=0.6u
X187 ypm zpp zpm avdd pfet_06v0 ad=1.98p pd=7.2u as=1.98p ps=7.2u w=6.6u l=0.6u
X188 a_3060_276# inp ypm avss nfet_06v0 ad=1.98p pd=7.2u as=1.98p ps=7.2u w=6.6u l=0.6u
X189 a_3348_276# bna a_3324_276# avss nfet_06v0 ad=1.98p pd=7.2u as=1.98p ps=7.2u w=6.6u l=0.6u
X190 ypp zpp zpp avdd pfet_06v0 ad=1.98p pd=7.2u as=1.98p ps=7.2u w=6.6u l=0.6u
X191 o znm a_5988_108# avss nfet_06v0 ad=1.98p pd=7.2u as=1.98p ps=7.2u w=6.6u l=0.6u
X192 a_3636_276# znp a_3612_276# avss nfet_06v0 ad=1.98p pd=7.2u as=1.98p ps=7.2u w=6.6u l=0.6u
X193 a_3156_816# zpp a_3132_816# avdd pfet_06v0 ad=1.98p pd=7.2u as=1.98p ps=7.2u w=6.6u l=0.6u
X194 a_2172_276# znp a_2148_276# avss nfet_06v0 ad=1.98p pd=7.2u as=1.98p ps=7.2u w=6.6u l=0.6u
X195 a_3924_276# znp znp avss nfet_06v0 ad=1.98p pd=7.2u as=1.98p ps=7.2u w=6.6u l=0.6u
X196 a_3444_816# zpp a_3420_816# avdd pfet_06v0 ad=1.98p pd=7.2u as=1.98p ps=7.2u w=6.6u l=0.6u
X197 a_3732_816# bpa a_3660_816# avdd pfet_06v0 ad=1.98p pd=7.2u as=1.98p ps=7.2u w=6.6u l=0.6u
X198 a_2820_108# bna a_2796_108# avss nfet_06v0 ad=1.98p pd=7.2u as=1.98p ps=7.2u w=6.6u l=0.6u
X199 bna_ bnb a_1044_108# avss nfet_06v0 ad=1.98p pd=7.2u as=1.98p ps=7.2u w=6.6u l=0.6u
X200 avdd zpp a_5316_984# avdd pfet_06v0 ad=1.98p pd=7.2u as=1.98p ps=7.2u w=6.6u l=0.6u
X201 znm bpb zpm avdd pfet_06v0 ad=1.98p pd=7.2u as=1.98p ps=7.2u w=6.6u l=0.6u
X202 bna_ bnb a_1332_108# avss nfet_06v0 ad=1.98p pd=7.2u as=1.98p ps=7.2u w=6.6u l=0.6u
X203 avdd zpm o avdd pfet_06v0 ad=1.98p pd=7.2u as=1.98p ps=7.2u w=6.6u l=0.6u
X204 avss bna a_1908_108# avss nfet_06v0 ad=1.98p pd=7.2u as=1.98p ps=7.2u w=6.6u l=0.6u
X205 a_1644_108# bna a_1620_108# avss nfet_06v0 ad=1.98p pd=7.2u as=1.98p ps=7.2u w=6.6u l=0.6u
X206 a_4164_984# zpp avdd avdd pfet_06v0 ad=1.98p pd=7.2u as=1.98p ps=7.2u w=6.6u l=0.6u
X207 a_4452_984# zpp a_4428_984# avdd pfet_06v0 ad=1.98p pd=7.2u as=1.98p ps=7.2u w=6.6u l=0.6u
X208 a_3828_276# znp znp avss nfet_06v0 ad=1.98p pd=7.2u as=1.98p ps=7.2u w=6.6u l=0.6u
X209 a_3540_276# znp a_3516_276# avss nfet_06v0 ad=1.98p pd=7.2u as=1.98p ps=7.2u w=6.6u l=0.6u
X210 a_3060_816# zpp a_3036_816# avdd pfet_06v0 ad=1.98p pd=7.2u as=1.98p ps=7.2u w=6.6u l=0.6u
X211 a_3348_816# zpp a_3324_816# avdd pfet_06v0 ad=1.98p pd=7.2u as=1.98p ps=7.2u w=6.6u l=0.6u
X212 a_2076_276# znp a_2052_276# avss nfet_06v0 ad=1.98p pd=7.2u as=1.98p ps=7.2u w=6.6u l=0.6u
X213 a_2364_276# znp a_2340_276# avss nfet_06v0 ad=1.98p pd=7.2u as=1.98p ps=7.2u w=6.6u l=0.6u
X214 znp bpb a_3564_816# avdd pfet_06v0 ad=1.98p pd=7.2u as=1.98p ps=7.2u w=6.6u l=0.6u
X215 a_2652_276# znp a_2628_276# avss nfet_06v0 ad=1.98p pd=7.2u as=1.98p ps=7.2u w=6.6u l=0.6u
X216 xp0 inp ynm avdd pfet_06v0 ad=1.98p pd=7.2u as=1.98p ps=7.2u w=6.6u l=0.6u
X217 znp bpb a_3900_816# avdd pfet_06v0 ad=1.98p pd=7.2u as=1.98p ps=7.2u w=6.6u l=0.6u
X218 bna_ bnb a_1236_108# avss nfet_06v0 ad=1.98p pd=7.2u as=1.98p ps=7.2u w=6.6u l=0.6u
X219 avss bna a_1524_108# avss nfet_06v0 ad=1.98p pd=7.2u as=1.98p ps=7.2u w=6.6u l=0.6u
X220 a_4068_984# bpa a_3996_816# avdd pfet_06v0 ad=1.98p pd=7.2u as=1.98p ps=7.2u w=6.6u l=0.6u
X221 a_5820_984# zpp a_5796_984# avdd pfet_06v0 ad=1.98p pd=7.2u as=1.98p ps=7.2u w=6.6u l=0.6u
X222 a_1836_108# bna a_1812_108# avss nfet_06v0 ad=1.98p pd=7.2u as=1.98p ps=7.2u w=6.6u l=0.6u
X223 zpp zpp ypp avdd pfet_06v0 ad=1.98p pd=7.2u as=1.98p ps=7.2u w=6.6u l=0.6u
X224 zpp zpp ypp avdd pfet_06v0 ad=1.98p pd=7.2u as=1.98p ps=7.2u w=6.6u l=0.6u
X225 zpm zpp ypm avdd pfet_06v0 ad=1.98p pd=7.2u as=1.98p ps=7.2u w=6.6u l=0.6u
X226 a_2268_276# znp a_2244_276# avss nfet_06v0 ad=1.98p pd=7.2u as=1.98p ps=7.2u w=6.6u l=0.6u
X227 a_3540_816# bpa a_3516_816# avdd pfet_06v0 ad=1.98p pd=7.2u as=1.98p ps=7.2u w=6.6u l=0.6u
X228 a_3828_816# bpa avdd avdd pfet_06v0 ad=1.98p pd=7.2u as=1.98p ps=7.2u w=6.6u l=0.6u
X229 a_2556_276# znp a_2532_276# avss nfet_06v0 ad=1.98p pd=7.2u as=1.98p ps=7.2u w=6.6u l=0.6u
X230 a_2844_276# bna a_2820_276# avss nfet_06v0 ad=1.98p pd=7.2u as=1.98p ps=7.2u w=6.6u l=0.6u
X231 xp0 inm ynp avdd pfet_06v0 ad=1.98p pd=7.2u as=1.98p ps=7.2u w=6.6u l=0.6u
X232 a_2364_816# bpa a_2340_816# avdd pfet_06v0 ad=1.98p pd=7.2u as=1.98p ps=7.2u w=6.6u l=0.6u
X233 a_1092_276# bnb bna_ avss nfet_06v0 ad=1.98p pd=7.2u as=1.98p ps=7.2u w=6.6u l=0.6u
X234 a_2652_816# bpa a_2628_816# avdd pfet_06v0 ad=1.98p pd=7.2u as=1.98p ps=7.2u w=6.6u l=0.6u
X235 bpb bna a_1716_108# avss nfet_06v0 ad=1.98p pd=7.2u as=1.98p ps=7.2u w=6.6u l=0.6u
X236 zpp zpp ypp avdd pfet_06v0 ad=1.98p pd=7.2u as=1.98p ps=7.2u w=6.6u l=0.6u
X237 a_4548_984# zpp a_4524_984# avdd pfet_06v0 ad=1.98p pd=7.2u as=1.98p ps=7.2u w=6.6u l=0.6u
X238 avdd zpp a_3060_984# avdd pfet_06v0 ad=1.98p pd=7.2u as=1.98p ps=7.2u w=6.6u l=0.6u
X239 a_4836_984# zpp avdd avdd pfet_06v0 ad=1.98p pd=7.2u as=1.98p ps=7.2u w=6.6u l=0.6u
X240 ypp zpp a_3348_984# avdd pfet_06v0 ad=1.98p pd=7.2u as=1.98p ps=7.2u w=6.6u l=0.6u
X241 a_2460_276# znp a_2436_276# avss nfet_06v0 ad=1.98p pd=7.2u as=1.98p ps=7.2u w=6.6u l=0.6u
X242 a_2748_276# bna a_2724_276# avss nfet_06v0 ad=1.98p pd=7.2u as=1.98p ps=7.2u w=6.6u l=0.6u
X243 a_5124_108# znp ynm avss nfet_06v0 ad=1.98p pd=7.2u as=1.98p ps=7.2u w=6.6u l=0.6u
X244 a_2268_816# bpa a_2244_816# avdd pfet_06v0 ad=1.98p pd=7.2u as=1.98p ps=7.2u w=6.6u l=0.6u
X245 a_1284_276# bnb bna_ avss nfet_06v0 ad=1.98p pd=7.2u as=1.98p ps=7.2u w=6.6u l=0.6u
X246 a_5412_108# bnb zpm avss nfet_06v0 ad=1.98p pd=7.2u as=1.98p ps=7.2u w=6.6u l=0.6u
X247 xp1 inm ynp avdd pfet_06v0 ad=1.98p pd=7.2u as=1.98p ps=7.2u w=6.6u l=0.6u
X248 a_2844_816# zpp a_2820_816# avdd pfet_06v0 ad=1.98p pd=7.2u as=1.98p ps=7.2u w=6.6u l=0.6u
X249 a_1572_276# bna avss avss nfet_06v0 ad=1.98p pd=7.2u as=1.98p ps=7.2u w=6.6u l=0.6u
X250 bpb bpb bpa_ avdd pfet_06v0 ad=1.98p pd=7.2u as=1.98p ps=7.2u w=6.6u l=0.6u
X251 a_4740_984# zpp ypp avdd pfet_06v0 ad=1.98p pd=7.2u as=1.98p ps=7.2u w=6.6u l=0.6u
X252 a_6132_276# znm o avss nfet_06v0 ad=1.98p pd=7.2u as=1.98p ps=7.2u w=6.6u l=0.6u
X253 avdd zpp a_3252_984# avdd pfet_06v0 ad=1.98p pd=7.2u as=1.98p ps=7.2u w=6.6u l=0.6u
X254 a_132_984# en avdd avdd pfet_06v0 ad=1.98p pd=7.2u as=3.96p ps=14.4u w=6.6u l=0.6u
X255 a_3564_816# bpa a_3540_984# avdd pfet_06v0 ad=1.98p pd=7.2u as=1.98p ps=7.2u w=6.6u l=0.6u
X256 a_5028_108# znp ynm avss nfet_06v0 ad=1.98p pd=7.2u as=1.98p ps=7.2u w=6.6u l=0.6u
X257 a_3852_984# bpa a_3828_984# avdd pfet_06v0 ad=1.98p pd=7.2u as=1.98p ps=7.2u w=6.6u l=0.6u
X258 ypp inm a_2916_276# avss nfet_06v0 ad=1.98p pd=7.2u as=1.98p ps=7.2u w=6.6u l=0.6u
X259 a_5316_108# bnb zpm avss nfet_06v0 ad=1.98p pd=7.2u as=1.98p ps=7.2u w=6.6u l=0.6u
X260 xp1 inp ynm avdd pfet_06v0 ad=1.98p pd=7.2u as=1.98p ps=7.2u w=6.6u l=0.6u
X261 a_1188_276# bnb bna_ avss nfet_06v0 ad=1.98p pd=7.2u as=1.98p ps=7.2u w=6.6u l=0.6u
X262 a_1476_276# bna a_1452_276# avss nfet_06v0 ad=1.98p pd=7.2u as=1.98p ps=7.2u w=6.6u l=0.6u
X263 a_2748_816# zpp a_2724_816# avdd pfet_06v0 ad=1.98p pd=7.2u as=1.98p ps=7.2u w=6.6u l=0.6u
X264 a_1764_276# bna bpb avss nfet_06v0 ad=1.98p pd=7.2u as=1.98p ps=7.2u w=6.6u l=0.6u
X265 bpb bpb bpa_ avdd pfet_06v0 ad=1.98p pd=7.2u as=1.98p ps=7.2u w=6.6u l=0.6u
X266 a_1560_811# a_1560_811# avdd avdd pfet_06v0 ad=1.98p pd=7.2u as=1.98p ps=7.2u w=6.6u l=0.6u
X267 a_6036_276# znm o avss nfet_06v0 ad=1.98p pd=7.2u as=1.98p ps=7.2u w=6.6u l=0.6u
X268 ypm zpp a_3156_984# avdd pfet_06v0 ad=1.98p pd=7.2u as=1.98p ps=7.2u w=6.6u l=0.6u
X269 a_6324_276# enb znm avss nfet_06v0 ad=1.98p pd=7.2u as=1.98p ps=7.2u w=6.6u l=0.6u
X270 avdd zpp a_3444_984# avdd pfet_06v0 ad=1.98p pd=7.2u as=1.98p ps=7.2u w=6.6u l=0.6u
X271 a_3756_984# bpa a_3732_984# avdd pfet_06v0 ad=1.98p pd=7.2u as=1.98p ps=7.2u w=6.6u l=0.6u
X272 o zpm avdd avdd pfet_06v0 ad=1.98p pd=7.2u as=1.98p ps=7.2u w=6.6u l=0.6u
X273 a_324_984# enb bpa_ avdd pfet_06v0 ad=1.98p pd=7.2u as=1.98p ps=7.2u w=6.6u l=0.6u
X274 bpb bpb bpa_ avdd pfet_06v0 ad=1.98p pd=7.2u as=1.98p ps=7.2u w=6.6u l=0.6u
X275 a_2292_984# bpa a_2268_984# avdd pfet_06v0 ad=1.98p pd=7.2u as=1.98p ps=7.2u w=6.6u l=0.6u
X276 a_5220_108# bnb zpm avss nfet_06v0 ad=1.98p pd=7.2u as=1.98p ps=7.2u w=6.6u l=0.6u
X277 a_1380_276# bna bna_ avss nfet_06v0 ad=1.98p pd=7.2u as=1.98p ps=7.2u w=6.6u l=0.6u
X278 bpb bpb bpa_ avdd pfet_06v0 ad=1.98p pd=7.2u as=1.98p ps=7.2u w=6.6u l=0.6u
X279 a_2940_816# zpp a_2916_816# avdd pfet_06v0 ad=1.98p pd=7.2u as=1.98p ps=7.2u w=6.6u l=0.6u
X280 a_1668_276# bna a_1644_276# avss nfet_06v0 ad=1.98p pd=7.2u as=1.98p ps=7.2u w=6.6u l=0.6u
X281 a_1956_276# znp avss avss nfet_06v0 ad=1.98p pd=7.2u as=1.98p ps=7.2u w=6.6u l=0.6u
X282 a_4332_108# bna a_4308_108# avss nfet_06v0 ad=1.98p pd=7.2u as=1.98p ps=7.2u w=6.6u l=0.6u
X283 a_4044_108# znp a_4020_108# avss nfet_06v0 ad=1.98p pd=7.2u as=1.98p ps=7.2u w=6.6u l=0.6u
X284 a_1476_816# bpa bpa_ avdd pfet_06v0 ad=1.98p pd=7.2u as=1.98p ps=7.2u w=6.6u l=0.6u
X285 a_1560_811# a_1560_811# a_1740_816# avdd pfet_06v0 ad=1.98p pd=7.2u as=1.98p ps=7.2u w=6.6u l=0.6u
X286 a_6228_276# znm o avss nfet_06v0 ad=1.98p pd=7.2u as=1.98p ps=7.2u w=6.6u l=0.6u
X287 a_804_108# bnb bna_ avss nfet_06v0 ad=1.98p pd=7.2u as=1.98p ps=7.2u w=6.6u l=0.6u
X288 a_228_984# en avdd avdd pfet_06v0 ad=1.98p pd=7.2u as=1.98p ps=7.2u w=6.6u l=0.6u
X289 a_3660_816# bpb znp avdd pfet_06v0 ad=1.98p pd=7.2u as=1.98p ps=7.2u w=6.6u l=0.6u
X290 o zpm avdd avdd pfet_06v0 ad=1.98p pd=7.2u as=1.98p ps=7.2u w=6.6u l=0.6u
X291 znm znp a_5028_276# avss nfet_06v0 ad=1.98p pd=7.2u as=1.98p ps=7.2u w=6.6u l=0.6u
X292 bpb bpb bpa_ avdd pfet_06v0 ad=1.98p pd=7.2u as=1.98p ps=7.2u w=6.6u l=0.6u
X293 ynm inp xp0 avdd pfet_06v0 ad=1.98p pd=7.2u as=1.98p ps=7.2u w=6.6u l=0.6u
X294 a_3900_816# bpb znp avdd pfet_06v0 ad=1.98p pd=7.2u as=1.98p ps=7.2u w=6.6u l=0.6u
X295 a_6324_816# en zpm avdd pfet_06v0 ad=1.98p pd=7.2u as=1.98p ps=7.2u w=6.6u l=0.6u
X296 ynm inp xp1 avdd pfet_06v0 ad=1.98p pd=7.2u as=1.98p ps=7.2u w=6.6u l=0.6u
X297 a_2772_984# zpp a_2748_984# avdd pfet_06v0 ad=1.98p pd=7.2u as=1.98p ps=7.2u w=6.6u l=0.6u
X298 a_1860_276# bna a_1836_276# avss nfet_06v0 ad=1.98p pd=7.2u as=1.98p ps=7.2u w=6.6u l=0.6u
X299 a_4236_108# bna a_4212_108# avss nfet_06v0 ad=1.98p pd=7.2u as=1.98p ps=7.2u w=6.6u l=0.6u
X300 bpb bpb bpa_ avdd pfet_06v0 ad=1.98p pd=7.2u as=1.98p ps=7.2u w=6.6u l=0.6u
X301 a_4332_108# bnb a_4500_108# avss nfet_06v0 ad=1.98p pd=7.2u as=1.98p ps=7.2u w=6.6u l=0.6u
X302 avss bna a_4788_108# avss nfet_06v0 ad=1.98p pd=7.2u as=1.98p ps=7.2u w=6.6u l=0.6u
X303 a_1560_811# a_1560_811# a_1644_816# avdd pfet_06v0 ad=1.98p pd=7.2u as=1.98p ps=7.2u w=6.6u l=0.6u
X304 a_1956_816# bpa avdd avdd pfet_06v0 ad=1.98p pd=7.2u as=1.98p ps=7.2u w=6.6u l=0.6u
X305 a_708_108# bnb bna_ avss nfet_06v0 ad=1.98p pd=7.2u as=1.98p ps=7.2u w=6.6u l=0.6u
X306 a_996_108# bnb bna_ avss nfet_06v0 ad=1.98p pd=7.2u as=1.98p ps=7.2u w=6.6u l=0.6u
X307 a_420_984# bpa avdd avdd pfet_06v0 ad=1.98p pd=7.2u as=1.98p ps=7.2u w=6.6u l=0.6u
X308 o zpm avdd avdd pfet_06v0 ad=1.98p pd=7.2u as=1.98p ps=7.2u w=6.6u l=0.6u
X309 znm bnb a_5220_276# avss nfet_06v0 ad=1.98p pd=7.2u as=1.98p ps=7.2u w=6.6u l=0.6u
X310 ynp inm xp0 avdd pfet_06v0 ad=1.98p pd=7.2u as=1.98p ps=7.2u w=6.6u l=0.6u
X311 a_2388_984# bpa a_2364_984# avdd pfet_06v0 ad=1.98p pd=7.2u as=1.98p ps=7.2u w=6.6u l=0.6u
X312 znm bnb a_5508_276# avss nfet_06v0 ad=1.98p pd=7.2u as=1.98p ps=7.2u w=6.6u l=0.6u
X313 a_2676_984# bpa a_2652_984# avdd pfet_06v0 ad=1.98p pd=7.2u as=1.98p ps=7.2u w=6.6u l=0.6u
X314 znm bpb zpm avdd pfet_06v0 ad=1.98p pd=7.2u as=1.98p ps=7.2u w=6.6u l=0.6u
X315 avss znp a_4116_108# avss nfet_06v0 ad=1.98p pd=7.2u as=1.98p ps=7.2u w=6.6u l=0.6u
X316 a_2964_984# zpp a_2940_984# avdd pfet_06v0 ad=1.98p pd=7.2u as=1.98p ps=7.2u w=6.6u l=0.6u
X317 a_4332_108# bnb a_4404_108# avss nfet_06v0 ad=1.98p pd=7.2u as=1.98p ps=7.2u w=6.6u l=0.6u
X318 a_4716_108# bna a_4692_108# avss nfet_06v0 ad=1.98p pd=7.2u as=1.98p ps=7.2u w=6.6u l=0.6u
X319 a_1560_811# a_1560_811# a_1836_816# avdd pfet_06v0 ad=1.98p pd=7.2u as=1.98p ps=7.2u w=6.6u l=0.6u
X320 a_3252_108# inm ypp avss nfet_06v0 ad=1.98p pd=7.2u as=1.98p ps=7.2u w=6.6u l=0.6u
X321 a_900_108# bnb bna_ avss nfet_06v0 ad=1.98p pd=7.2u as=1.98p ps=7.2u w=6.6u l=0.6u
X322 znm znp a_5124_276# avss nfet_06v0 ad=1.98p pd=7.2u as=1.98p ps=7.2u w=6.6u l=0.6u
X323 a_5724_276# znp a_5700_276# avss nfet_06v0 ad=1.98p pd=7.2u as=1.98p ps=7.2u w=6.6u l=0.6u
X324 znm bnb a_5412_276# avss nfet_06v0 ad=1.98p pd=7.2u as=1.98p ps=7.2u w=6.6u l=0.6u
X325 ynp inm xp1 avdd pfet_06v0 ad=1.98p pd=7.2u as=1.98p ps=7.2u w=6.6u l=0.6u
X326 a_2868_984# zpp a_2844_984# avdd pfet_06v0 ad=1.98p pd=7.2u as=1.98p ps=7.2u w=6.6u l=0.6u
X327 ypm zpp zpm avdd pfet_06v0 ad=1.98p pd=7.2u as=1.98p ps=7.2u w=6.6u l=0.6u
X328 bpa_ bpb bpb avdd pfet_06v0 ad=1.98p pd=7.2u as=1.98p ps=7.2u w=6.6u l=0.6u
X329 znm bpb zpm avdd pfet_06v0 ad=1.98p pd=7.2u as=1.98p ps=7.2u w=6.6u l=0.6u
X330 a_4332_108# bnb a_4596_108# avss nfet_06v0 ad=1.98p pd=7.2u as=1.98p ps=7.2u w=6.6u l=0.6u
X331 a_1692_984# a_1560_811# a_1560_811# avdd pfet_06v0 ad=1.98p pd=7.2u as=1.98p ps=7.2u w=6.6u l=0.6u
X332 a_3156_108# inp ypm avss nfet_06v0 ad=1.98p pd=7.2u as=1.98p ps=7.2u w=6.6u l=0.6u
X333 a_3444_108# bna a_3420_108# avss nfet_06v0 ad=1.98p pd=7.2u as=1.98p ps=7.2u w=6.6u l=0.6u
X334 a_3732_108# znp znp avss nfet_06v0 ad=1.98p pd=7.2u as=1.98p ps=7.2u w=6.6u l=0.6u
X335 avdd zpm o avdd pfet_06v0 ad=1.98p pd=7.2u as=1.98p ps=7.2u w=6.6u l=0.6u
X336 znm bnb a_5316_276# avss nfet_06v0 ad=1.98p pd=7.2u as=1.98p ps=7.2u w=6.6u l=0.6u
X337 znm znp a_5604_276# avss nfet_06v0 ad=1.98p pd=7.2u as=1.98p ps=7.2u w=6.6u l=0.6u
X338 znm bpb zpm avdd pfet_06v0 ad=1.98p pd=7.2u as=1.98p ps=7.2u w=6.6u l=0.6u
X339 o znm a_5892_276# avss nfet_06v0 ad=1.98p pd=7.2u as=1.98p ps=7.2u w=6.6u l=0.6u
X340 a_4164_276# bna avss avss nfet_06v0 ad=1.98p pd=7.2u as=1.98p ps=7.2u w=6.6u l=0.6u
X341 bpa_ bpb bpb avdd pfet_06v0 ad=1.98p pd=7.2u as=1.98p ps=7.2u w=6.6u l=0.6u
X342 ypm zpp a_5412_816# avdd pfet_06v0 ad=1.98p pd=7.2u as=1.98p ps=7.2u w=6.6u l=0.6u
X343 ypm zpp zpm avdd pfet_06v0 ad=1.98p pd=7.2u as=1.98p ps=7.2u w=6.6u l=0.6u
X344 a_4452_276# bnb a_4332_108# avss nfet_06v0 ad=1.98p pd=7.2u as=1.98p ps=7.2u w=6.6u l=0.6u
X345 a_1596_984# a_1560_811# a_1560_811# avdd pfet_06v0 ad=1.98p pd=7.2u as=1.98p ps=7.2u w=6.6u l=0.6u
X346 a_1884_984# a_1560_811# a_1560_811# avdd pfet_06v0 ad=1.98p pd=7.2u as=1.98p ps=7.2u w=6.6u l=0.6u
X347 a_3060_108# inp ypm avss nfet_06v0 ad=1.98p pd=7.2u as=1.98p ps=7.2u w=6.6u l=0.6u
X348 a_3636_108# znp a_3612_108# avss nfet_06v0 ad=1.98p pd=7.2u as=1.98p ps=7.2u w=6.6u l=0.6u
X349 a_3348_108# bna a_3324_108# avss nfet_06v0 ad=1.98p pd=7.2u as=1.98p ps=7.2u w=6.6u l=0.6u
X350 avdd zpm o avdd pfet_06v0 ad=1.98p pd=7.2u as=1.98p ps=7.2u w=6.6u l=0.6u
X351 a_3924_108# znp znp avss nfet_06v0 ad=1.98p pd=7.2u as=1.98p ps=7.2u w=6.6u l=0.6u
X352 a_2172_108# znp a_2148_108# avss nfet_06v0 ad=1.98p pd=7.2u as=1.98p ps=7.2u w=6.6u l=0.6u
X353 a_5820_276# znp a_5796_276# avss nfet_06v0 ad=1.98p pd=7.2u as=1.98p ps=7.2u w=6.6u l=0.6u
X354 avdd zpp a_5316_816# avdd pfet_06v0 ad=1.98p pd=7.2u as=1.98p ps=7.2u w=6.6u l=0.6u
X355 a_4356_276# bnb a_4332_108# avss nfet_06v0 ad=1.98p pd=7.2u as=1.98p ps=7.2u w=6.6u l=0.6u
X356 a_4068_276# znp a_4044_276# avss nfet_06v0 ad=1.98p pd=7.2u as=1.98p ps=7.2u w=6.6u l=0.6u
X357 a_1500_984# bpa a_1476_984# avdd pfet_06v0 ad=1.98p pd=7.2u as=1.98p ps=7.2u w=6.6u l=0.6u
X358 znm bpb zpm avdd pfet_06v0 ad=1.98p pd=7.2u as=1.98p ps=7.2u w=6.6u l=0.6u
X359 a_4644_276# bna a_4332_108# avss nfet_06v0 ad=1.98p pd=7.2u as=1.98p ps=7.2u w=6.6u l=0.6u
X360 a_1788_984# a_1560_811# a_1560_811# avdd pfet_06v0 ad=1.98p pd=7.2u as=1.98p ps=7.2u w=6.6u l=0.6u
X361 a_4164_816# zpp avdd avdd pfet_06v0 ad=1.98p pd=7.2u as=1.98p ps=7.2u w=6.6u l=0.6u
X362 avdd zpm o avdd pfet_06v0 ad=1.98p pd=7.2u as=1.98p ps=7.2u w=6.6u l=0.6u
X363 a_4932_276# znp a_4908_276# avss nfet_06v0 ad=1.98p pd=7.2u as=1.98p ps=7.2u w=6.6u l=0.6u
X364 a_4452_816# zpp a_4428_816# avdd pfet_06v0 ad=1.98p pd=7.2u as=1.98p ps=7.2u w=6.6u l=0.6u
X365 a_3540_108# znp a_3516_108# avss nfet_06v0 ad=1.98p pd=7.2u as=1.98p ps=7.2u w=6.6u l=0.6u
X366 avdd zpm o avdd pfet_06v0 ad=1.98p pd=7.2u as=1.98p ps=7.2u w=6.6u l=0.6u
X367 a_3828_108# znp znp avss nfet_06v0 ad=1.98p pd=7.2u as=1.98p ps=7.2u w=6.6u l=0.6u
X368 a_2076_108# znp a_2052_108# avss nfet_06v0 ad=1.98p pd=7.2u as=1.98p ps=7.2u w=6.6u l=0.6u
X369 avdd en a_6324_984# avdd pfet_06v0 ad=3.96p pd=14.4u as=1.98p ps=7.2u w=6.6u l=0.6u
X370 a_2364_108# znp a_2340_108# avss nfet_06v0 ad=1.98p pd=7.2u as=1.98p ps=7.2u w=6.6u l=0.6u
X371 zpm bpb znm avdd pfet_06v0 ad=1.98p pd=7.2u as=1.98p ps=7.2u w=6.6u l=0.6u
X372 a_2652_108# znp a_2628_108# avss nfet_06v0 ad=1.98p pd=7.2u as=1.98p ps=7.2u w=6.6u l=0.6u
X373 a_4260_276# bna a_4236_276# avss nfet_06v0 ad=1.98p pd=7.2u as=1.98p ps=7.2u w=6.6u l=0.6u
X374 a_4068_816# bpa a_3996_816# avdd pfet_06v0 ad=1.98p pd=7.2u as=1.98p ps=7.2u w=6.6u l=0.6u
X375 a_5820_816# zpp a_5796_816# avdd pfet_06v0 ad=1.98p pd=7.2u as=1.98p ps=7.2u w=6.6u l=0.6u
X376 a_4836_276# znp avss avss nfet_06v0 ad=1.98p pd=7.2u as=1.98p ps=7.2u w=6.6u l=0.6u
X377 a_4548_276# bnb a_4332_108# avss nfet_06v0 ad=1.98p pd=7.2u as=1.98p ps=7.2u w=6.6u l=0.6u
X378 a_1980_984# bpa a_1956_984# avdd pfet_06v0 ad=1.98p pd=7.2u as=1.98p ps=7.2u w=6.6u l=0.6u
X379 zpp zpp ypp avdd pfet_06v0 ad=1.98p pd=7.2u as=1.98p ps=7.2u w=6.6u l=0.6u
X380 xn inp a_3060_276# avss nfet_06v0 ad=1.98p pd=7.2u as=1.98p ps=7.2u w=6.6u l=0.6u
X381 a_3372_276# bna a_3348_276# avss nfet_06v0 ad=1.98p pd=7.2u as=1.98p ps=7.2u w=6.6u l=0.6u
X382 zpp zpp ypp avdd pfet_06v0 ad=1.98p pd=7.2u as=1.98p ps=7.2u w=6.6u l=0.6u
X383 zpm zpp ypm avdd pfet_06v0 ad=1.98p pd=7.2u as=1.98p ps=7.2u w=6.6u l=0.6u
X384 a_2268_108# znp a_2244_108# avss nfet_06v0 ad=1.98p pd=7.2u as=1.98p ps=7.2u w=6.6u l=0.6u
X385 a_2556_108# znp a_2532_108# avss nfet_06v0 ad=1.98p pd=7.2u as=1.98p ps=7.2u w=6.6u l=0.6u
X386 zpm bpb znm avdd pfet_06v0 ad=1.98p pd=7.2u as=1.98p ps=7.2u w=6.6u l=0.6u
X387 a_2844_108# bna a_2820_108# avss nfet_06v0 ad=1.98p pd=7.2u as=1.98p ps=7.2u w=6.6u l=0.6u
X388 a_1092_108# bnb bna_ avss nfet_06v0 ad=1.98p pd=7.2u as=1.98p ps=7.2u w=6.6u l=0.6u
X389 a_5364_984# zpp avdd avdd pfet_06v0 ad=1.98p pd=7.2u as=1.98p ps=7.2u w=6.6u l=0.6u
X390 zpm bpb znm avdd pfet_06v0 ad=1.98p pd=7.2u as=1.98p ps=7.2u w=6.6u l=0.6u
X391 a_4740_276# bna a_4716_276# avss nfet_06v0 ad=1.98p pd=7.2u as=1.98p ps=7.2u w=6.6u l=0.6u
X392 zpp zpp ypp avdd pfet_06v0 ad=1.98p pd=7.2u as=1.98p ps=7.2u w=6.6u l=0.6u
X393 a_4548_816# zpp a_4524_816# avdd pfet_06v0 ad=1.98p pd=7.2u as=1.98p ps=7.2u w=6.6u l=0.6u
X394 xn inm a_3252_276# avss nfet_06v0 ad=1.98p pd=7.2u as=1.98p ps=7.2u w=6.6u l=0.6u
X395 a_4836_816# zpp avdd avdd pfet_06v0 ad=1.98p pd=7.2u as=1.98p ps=7.2u w=6.6u l=0.6u
X396 a_132_276# en avss avss nfet_06v0 ad=1.98p pd=7.2u as=3.96p ps=14.4u w=6.6u l=0.6u
X397 ynp znp a_3828_276# avss nfet_06v0 ad=1.98p pd=7.2u as=1.98p ps=7.2u w=6.6u l=0.6u
X398 a_3564_276# znp a_3540_276# avss nfet_06v0 ad=1.98p pd=7.2u as=1.98p ps=7.2u w=6.6u l=0.6u
X399 avdd zpp a_3060_816# avdd pfet_06v0 ad=1.98p pd=7.2u as=1.98p ps=7.2u w=6.6u l=0.6u
X400 ypp zpp a_3348_816# avdd pfet_06v0 ad=1.98p pd=7.2u as=1.98p ps=7.2u w=6.6u l=0.6u
X401 a_2748_108# bna a_2724_108# avss nfet_06v0 ad=1.98p pd=7.2u as=1.98p ps=7.2u w=6.6u l=0.6u
X402 a_2460_108# znp a_2436_108# avss nfet_06v0 ad=1.98p pd=7.2u as=1.98p ps=7.2u w=6.6u l=0.6u
X403 a_5268_984# zpp ypm avdd pfet_06v0 ad=1.98p pd=7.2u as=1.98p ps=7.2u w=6.6u l=0.6u
X404 a_1284_108# bnb bna_ avss nfet_06v0 ad=1.98p pd=7.2u as=1.98p ps=7.2u w=6.6u l=0.6u
X405 zpm bpb znm avdd pfet_06v0 ad=1.98p pd=7.2u as=1.98p ps=7.2u w=6.6u l=0.6u
X406 a_1572_108# bna avss avss nfet_06v0 ad=1.98p pd=7.2u as=1.98p ps=7.2u w=6.6u l=0.6u
X407 a_4092_984# bpa a_4068_984# avdd pfet_06v0 ad=1.98p pd=7.2u as=1.98p ps=7.2u w=6.6u l=0.6u
X408 a_5844_984# zpp a_5820_984# avdd pfet_06v0 ad=1.98p pd=7.2u as=1.98p ps=7.2u w=6.6u l=0.6u
X409 xn inp a_3156_276# avss nfet_06v0 ad=1.98p pd=7.2u as=1.98p ps=7.2u w=6.6u l=0.6u
X410 avss bna a_3444_276# avss nfet_06v0 ad=1.98p pd=7.2u as=1.98p ps=7.2u w=6.6u l=0.6u
X411 a_4740_816# zpp ypp avdd pfet_06v0 ad=1.98p pd=7.2u as=1.98p ps=7.2u w=6.6u l=0.6u
X412 a_324_276# en bna_ avss nfet_06v0 ad=1.98p pd=7.2u as=1.98p ps=7.2u w=6.6u l=0.6u
X413 a_6132_108# znm o avss nfet_06v0 ad=1.98p pd=7.2u as=1.98p ps=7.2u w=6.6u l=0.6u
X414 ynp znp a_3732_276# avss nfet_06v0 ad=1.98p pd=7.2u as=1.98p ps=7.2u w=6.6u l=0.6u
X415 avdd zpp a_3252_816# avdd pfet_06v0 ad=1.98p pd=7.2u as=1.98p ps=7.2u w=6.6u l=0.6u
X416 a_612_276# bnb bna_ avss nfet_06v0 ad=1.98p pd=7.2u as=1.98p ps=7.2u w=6.6u l=0.6u
X417 a_2292_276# znp a_2268_276# avss nfet_06v0 ad=1.98p pd=7.2u as=1.98p ps=7.2u w=6.6u l=0.6u
X418 a_132_816# en avdd avdd pfet_06v0 ad=1.98p pd=7.2u as=3.96p ps=14.4u w=6.6u l=0.6u
X419 a_3564_816# bpa a_3540_816# avdd pfet_06v0 ad=1.98p pd=7.2u as=1.98p ps=7.2u w=6.6u l=0.6u
X420 a_3852_816# bpa a_3828_816# avdd pfet_06v0 ad=1.98p pd=7.2u as=1.98p ps=7.2u w=6.6u l=0.6u
X421 ypp inm a_2916_108# avss nfet_06v0 ad=1.98p pd=7.2u as=1.98p ps=7.2u w=6.6u l=0.6u
X422 a_1188_108# bnb bna_ avss nfet_06v0 ad=1.98p pd=7.2u as=1.98p ps=7.2u w=6.6u l=0.6u
X423 zpm zpp ypm avdd pfet_06v0 ad=1.98p pd=7.2u as=1.98p ps=7.2u w=6.6u l=0.6u
X424 zpm zpp ypm avdd pfet_06v0 ad=1.98p pd=7.2u as=1.98p ps=7.2u w=6.6u l=0.6u
X425 a_1764_108# bna bpb avss nfet_06v0 ad=1.98p pd=7.2u as=1.98p ps=7.2u w=6.6u l=0.6u
X426 a_1476_108# bna a_1452_108# avss nfet_06v0 ad=1.98p pd=7.2u as=1.98p ps=7.2u w=6.6u l=0.6u
X427 ypp zpp zpp avdd pfet_06v0 ad=1.98p pd=7.2u as=1.98p ps=7.2u w=6.6u l=0.6u
X428 ypp zpp a_4548_984# avdd pfet_06v0 ad=1.98p pd=7.2u as=1.98p ps=7.2u w=6.6u l=0.6u
X429 a_6036_108# znm o avss nfet_06v0 ad=1.98p pd=7.2u as=1.98p ps=7.2u w=6.6u l=0.6u
X430 ynp znp a_3636_276# avss nfet_06v0 ad=1.98p pd=7.2u as=1.98p ps=7.2u w=6.6u l=0.6u
X431 ypm zpp a_3156_816# avdd pfet_06v0 ad=1.98p pd=7.2u as=1.98p ps=7.2u w=6.6u l=0.6u
X432 a_228_276# enb avss avss nfet_06v0 ad=1.98p pd=7.2u as=1.98p ps=7.2u w=6.6u l=0.6u
X433 a_516_276# bna a_492_276# avss nfet_06v0 ad=1.98p pd=7.2u as=1.98p ps=7.2u w=6.6u l=0.6u
X434 a_2196_276# znp a_2172_276# avss nfet_06v0 ad=1.98p pd=7.2u as=1.98p ps=7.2u w=6.6u l=0.6u
X435 a_6324_108# enb znm avss nfet_06v0 ad=1.98p pd=7.2u as=1.98p ps=7.2u w=6.6u l=0.6u
X436 ynp znp a_3924_276# avss nfet_06v0 ad=1.98p pd=7.2u as=1.98p ps=7.2u w=6.6u l=0.6u
X437 avdd zpp a_3444_816# avdd pfet_06v0 ad=1.98p pd=7.2u as=1.98p ps=7.2u w=6.6u l=0.6u
X438 a_2484_276# znp a_2460_276# avss nfet_06v0 ad=1.98p pd=7.2u as=1.98p ps=7.2u w=6.6u l=0.6u
X439 a_324_816# enb bpa_ avdd pfet_06v0 ad=1.98p pd=7.2u as=1.98p ps=7.2u w=6.6u l=0.6u
X440 a_3756_816# bpa a_3732_816# avdd pfet_06v0 ad=1.98p pd=7.2u as=1.98p ps=7.2u w=6.6u l=0.6u
X441 a_2772_276# bna a_2748_276# avss nfet_06v0 ad=1.98p pd=7.2u as=1.98p ps=7.2u w=6.6u l=0.6u
X442 bpb bpb bpa_ avdd pfet_06v0 ad=1.98p pd=7.2u as=1.98p ps=7.2u w=6.6u l=0.6u
X443 a_2292_816# bpa a_2268_816# avdd pfet_06v0 ad=1.98p pd=7.2u as=1.98p ps=7.2u w=6.6u l=0.6u
X444 a_1380_108# bna bna_ avss nfet_06v0 ad=1.98p pd=7.2u as=1.98p ps=7.2u w=6.6u l=0.6u
X445 a_1668_108# bna a_1644_108# avss nfet_06v0 ad=1.98p pd=7.2u as=1.98p ps=7.2u w=6.6u l=0.6u
X446 a_4188_984# zpp a_4164_984# avdd pfet_06v0 ad=1.98p pd=7.2u as=1.98p ps=7.2u w=6.6u l=0.6u
X447 o zpm avdd avdd pfet_06v0 ad=1.98p pd=7.2u as=1.98p ps=7.2u w=6.6u l=0.6u
X448 a_1956_108# znp avss avss nfet_06v0 ad=1.98p pd=7.2u as=1.98p ps=7.2u w=6.6u l=0.6u
X449 avdd zpp a_4452_984# avdd pfet_06v0 ad=1.98p pd=7.2u as=1.98p ps=7.2u w=6.6u l=0.6u
X450 a_4764_984# zpp a_4740_984# avdd pfet_06v0 ad=1.98p pd=7.2u as=1.98p ps=7.2u w=6.6u l=0.6u
X451 a_420_276# bna avss avss nfet_06v0 ad=1.98p pd=7.2u as=1.98p ps=7.2u w=6.6u l=0.6u
X452 a_2100_276# znp a_2076_276# avss nfet_06v0 ad=1.98p pd=7.2u as=1.98p ps=7.2u w=6.6u l=0.6u
X453 a_6228_108# znm o avss nfet_06v0 ad=1.98p pd=7.2u as=1.98p ps=7.2u w=6.6u l=0.6u
X454 a_228_816# en avdd avdd pfet_06v0 ad=1.98p pd=7.2u as=1.98p ps=7.2u w=6.6u l=0.6u
X455 a_3660_816# bpb znp avdd pfet_06v0 ad=1.98p pd=7.2u as=1.98p ps=7.2u w=6.6u l=0.6u
X456 a_2388_276# znp a_2364_276# avss nfet_06v0 ad=1.98p pd=7.2u as=1.98p ps=7.2u w=6.6u l=0.6u
X457 znm znp a_5028_108# avss nfet_06v0 ad=1.98p pd=7.2u as=1.98p ps=7.2u w=6.6u l=0.6u
X458 bpb bpb bpa_ avdd pfet_06v0 ad=1.98p pd=7.2u as=1.98p ps=7.2u w=6.6u l=0.6u
X459 ynm inp xp0 avdd pfet_06v0 ad=1.98p pd=7.2u as=1.98p ps=7.2u w=6.6u l=0.6u
X460 a_3900_816# bpb znp avdd pfet_06v0 ad=1.98p pd=7.2u as=1.98p ps=7.2u w=6.6u l=0.6u
X461 a_2676_276# znp a_2652_276# avss nfet_06v0 ad=1.98p pd=7.2u as=1.98p ps=7.2u w=6.6u l=0.6u
X462 a_2964_276# inm ypp avss nfet_06v0 ad=1.98p pd=7.2u as=1.98p ps=7.2u w=6.6u l=0.6u
X463 ynm inp xp1 avdd pfet_06v0 ad=1.98p pd=7.2u as=1.98p ps=7.2u w=6.6u l=0.6u
X464 a_2772_816# zpp a_2748_816# avdd pfet_06v0 ad=1.98p pd=7.2u as=1.98p ps=7.2u w=6.6u l=0.6u
X465 a_1860_108# bna a_1836_108# avss nfet_06v0 ad=1.98p pd=7.2u as=1.98p ps=7.2u w=6.6u l=0.6u
X466 ypp zpp zpp avdd pfet_06v0 ad=1.98p pd=7.2u as=1.98p ps=7.2u w=6.6u l=0.6u
X467 ypp zpp zpp avdd pfet_06v0 ad=1.98p pd=7.2u as=1.98p ps=7.2u w=6.6u l=0.6u
X468 a_3204_984# zpp ypm avdd pfet_06v0 ad=1.98p pd=7.2u as=1.98p ps=7.2u w=6.6u l=0.6u
X469 ypm zpp zpm avdd pfet_06v0 ad=1.98p pd=7.2u as=1.98p ps=7.2u w=6.6u l=0.6u
X470 a_3492_984# bpa avdd avdd pfet_06v0 ad=1.98p pd=7.2u as=1.98p ps=7.2u w=6.6u l=0.6u
X471 a_2580_276# znp a_2556_276# avss nfet_06v0 ad=1.98p pd=7.2u as=1.98p ps=7.2u w=6.6u l=0.6u
X472 a_420_816# bpa avdd avdd pfet_06v0 ad=1.98p pd=7.2u as=1.98p ps=7.2u w=6.6u l=0.6u
X473 ynp inm xp0 avdd pfet_06v0 ad=1.98p pd=7.2u as=1.98p ps=7.2u w=6.6u l=0.6u
X474 a_2868_276# bna a_2844_276# avss nfet_06v0 ad=1.98p pd=7.2u as=1.98p ps=7.2u w=6.6u l=0.6u
X475 znm bnb a_5220_108# avss nfet_06v0 ad=1.98p pd=7.2u as=1.98p ps=7.2u w=6.6u l=0.6u
X476 znm bnb a_5508_108# avss nfet_06v0 ad=1.98p pd=7.2u as=1.98p ps=7.2u w=6.6u l=0.6u
X477 a_2388_816# bpa a_2364_816# avdd pfet_06v0 ad=1.98p pd=7.2u as=1.98p ps=7.2u w=6.6u l=0.6u
X478 a_2676_816# bpa a_2652_816# avdd pfet_06v0 ad=1.98p pd=7.2u as=1.98p ps=7.2u w=6.6u l=0.6u
X479 a_1404_276# bna a_1380_276# avss nfet_06v0 ad=1.98p pd=7.2u as=1.98p ps=7.2u w=6.6u l=0.6u
X480 a_2964_816# zpp a_2940_816# avdd pfet_06v0 ad=1.98p pd=7.2u as=1.98p ps=7.2u w=6.6u l=0.6u
X481 a_1692_276# bna a_1668_276# avss nfet_06v0 ad=1.98p pd=7.2u as=1.98p ps=7.2u w=6.6u l=0.6u
X482 a_3108_984# zpp avdd avdd pfet_06v0 ad=1.98p pd=7.2u as=1.98p ps=7.2u w=6.6u l=0.6u
X483 a_4860_984# zpp a_4836_984# avdd pfet_06v0 ad=1.98p pd=7.2u as=1.98p ps=7.2u w=6.6u l=0.6u
X484 avss znm a_6228_276# avss nfet_06v0 ad=1.98p pd=7.2u as=1.98p ps=7.2u w=6.6u l=0.6u
X485 a_3396_984# zpp ypp avdd pfet_06v0 ad=1.98p pd=7.2u as=1.98p ps=7.2u w=6.6u l=0.6u
X486 bpa en a_228_984# avdd pfet_06v0 ad=1.98p pd=7.2u as=1.98p ps=7.2u w=6.6u l=0.6u
X487 znp bpb a_3660_816# avdd pfet_06v0 ad=1.98p pd=7.2u as=1.98p ps=7.2u w=6.6u l=0.6u
X488 znm znp a_5124_108# avss nfet_06v0 ad=1.98p pd=7.2u as=1.98p ps=7.2u w=6.6u l=0.6u
X489 znp bpb a_3900_816# avdd pfet_06v0 ad=1.98p pd=7.2u as=1.98p ps=7.2u w=6.6u l=0.6u
X490 bnb bnb a_1284_276# avss nfet_06v0 ad=1.98p pd=7.2u as=1.98p ps=7.2u w=6.6u l=0.6u
X491 znm bnb a_5412_108# avss nfet_06v0 ad=1.98p pd=7.2u as=1.98p ps=7.2u w=6.6u l=0.6u
X492 ynp inm xp1 avdd pfet_06v0 ad=1.98p pd=7.2u as=1.98p ps=7.2u w=6.6u l=0.6u
X493 a_1596_276# bna a_1572_276# avss nfet_06v0 ad=1.98p pd=7.2u as=1.98p ps=7.2u w=6.6u l=0.6u
X494 a_5724_108# znp a_5700_108# avss nfet_06v0 ad=1.98p pd=7.2u as=1.98p ps=7.2u w=6.6u l=0.6u
X495 a_2868_816# zpp a_2844_816# avdd pfet_06v0 ad=1.98p pd=7.2u as=1.98p ps=7.2u w=6.6u l=0.6u
X496 a_1884_276# bna a_1860_276# avss nfet_06v0 ad=1.98p pd=7.2u as=1.98p ps=7.2u w=6.6u l=0.6u
X497 bpa_ bpb bpb avdd pfet_06v0 ad=1.98p pd=7.2u as=1.98p ps=7.2u w=6.6u l=0.6u
X498 a_1692_816# a_1560_811# a_1560_811# avdd pfet_06v0 ad=1.98p pd=7.2u as=1.98p ps=7.2u w=6.6u l=0.6u
X499 avss znm a_6132_276# avss nfet_06v0 ad=1.98p pd=7.2u as=1.98p ps=7.2u w=6.6u l=0.6u
X500 a_3300_984# zpp avdd avdd pfet_06v0 ad=1.98p pd=7.2u as=1.98p ps=7.2u w=6.6u l=0.6u
X501 enb en a_132_984# avdd pfet_06v0 ad=1.98p pd=7.2u as=1.98p ps=7.2u w=6.6u l=0.6u
X502 a_444_984# bpa a_420_984# avdd pfet_06v0 ad=1.98p pd=7.2u as=1.98p ps=7.2u w=6.6u l=0.6u
X503 znp bpb a_3564_816# avdd pfet_06v0 ad=1.98p pd=7.2u as=1.98p ps=7.2u w=6.6u l=0.6u
X504 a_3876_984# bpa a_3852_984# avdd pfet_06v0 ad=1.98p pd=7.2u as=1.98p ps=7.2u w=6.6u l=0.6u
X505 avdd zpm o avdd pfet_06v0 ad=1.98p pd=7.2u as=1.98p ps=7.2u w=6.6u l=0.6u
X506 bpa_ bpb bpb avdd pfet_06v0 ad=1.98p pd=7.2u as=1.98p ps=7.2u w=6.6u l=0.6u
X507 znm bnb a_5316_108# avss nfet_06v0 ad=1.98p pd=7.2u as=1.98p ps=7.2u w=6.6u l=0.6u
X508 znm znp a_5604_108# avss nfet_06v0 ad=1.98p pd=7.2u as=1.98p ps=7.2u w=6.6u l=0.6u
X509 a_1500_276# bna a_1476_276# avss nfet_06v0 ad=1.98p pd=7.2u as=1.98p ps=7.2u w=6.6u l=0.6u
X510 a_1788_276# bna a_1764_276# avss nfet_06v0 ad=1.98p pd=7.2u as=1.98p ps=7.2u w=6.6u l=0.6u
X511 a_4164_108# bna avss avss nfet_06v0 ad=1.98p pd=7.2u as=1.98p ps=7.2u w=6.6u l=0.6u
X512 o znm a_5892_108# avss nfet_06v0 ad=1.98p pd=7.2u as=1.98p ps=7.2u w=6.6u l=0.6u
X513 bpa_ bpb bpb avdd pfet_06v0 ad=1.98p pd=7.2u as=1.98p ps=7.2u w=6.6u l=0.6u
X514 a_4452_108# bnb a_4332_108# avss nfet_06v0 ad=1.98p pd=7.2u as=1.98p ps=7.2u w=6.6u l=0.6u
X515 a_1596_816# a_1560_811# a_1560_811# avdd pfet_06v0 ad=1.98p pd=7.2u as=1.98p ps=7.2u w=6.6u l=0.6u
X516 avss znm a_6036_276# avss nfet_06v0 ad=1.98p pd=7.2u as=1.98p ps=7.2u w=6.6u l=0.6u
X517 a_1884_816# a_1560_811# a_1560_811# avdd pfet_06v0 ad=1.98p pd=7.2u as=1.98p ps=7.2u w=6.6u l=0.6u
X518 avss enb a_6324_276# avss nfet_06v0 ad=3.96p pd=14.4u as=1.98p ps=7.2u w=6.6u l=0.6u
X519 bpa enb a_324_984# avdd pfet_06v0 ad=1.98p pd=7.2u as=1.98p ps=7.2u w=6.6u l=0.6u
X520 a_3780_984# bpa a_3756_984# avdd pfet_06v0 ad=1.98p pd=7.2u as=1.98p ps=7.2u w=6.6u l=0.6u
X521 avdd zpm o avdd pfet_06v0 ad=1.98p pd=7.2u as=1.98p ps=7.2u w=6.6u l=0.6u
X522 a_5172_276# bnb znm avss nfet_06v0 ad=1.98p pd=7.2u as=1.98p ps=7.2u w=6.6u l=0.6u
X523 bpa_ bpb bpb avdd pfet_06v0 ad=1.98p pd=7.2u as=1.98p ps=7.2u w=6.6u l=0.6u
X524 a_924_984# bpa a_900_984# avdd pfet_06v0 ad=1.98p pd=7.2u as=1.98p ps=7.2u w=6.6u l=0.6u
X525 xp1 inm ynp avdd pfet_06v0 ad=1.98p pd=7.2u as=1.98p ps=7.2u w=6.6u l=0.6u
X526 avdd zpp a_2868_984# avdd pfet_06v0 ad=1.98p pd=7.2u as=1.98p ps=7.2u w=6.6u l=0.6u
X527 a_4068_108# znp a_4044_108# avss nfet_06v0 ad=1.98p pd=7.2u as=1.98p ps=7.2u w=6.6u l=0.6u
X528 a_5820_108# znp a_5796_108# avss nfet_06v0 ad=1.98p pd=7.2u as=1.98p ps=7.2u w=6.6u l=0.6u
X529 a_1980_276# znp a_1956_276# avss nfet_06v0 ad=1.98p pd=7.2u as=1.98p ps=7.2u w=6.6u l=0.6u
X530 a_4356_108# bnb a_4332_108# avss nfet_06v0 ad=1.98p pd=7.2u as=1.98p ps=7.2u w=6.6u l=0.6u
X531 a_4644_108# bna a_4332_108# avss nfet_06v0 ad=1.98p pd=7.2u as=1.98p ps=7.2u w=6.6u l=0.6u
X532 a_1500_816# bpa a_1476_816# avdd pfet_06v0 ad=1.98p pd=7.2u as=1.98p ps=7.2u w=6.6u l=0.6u
X533 a_1788_816# a_1560_811# a_1560_811# avdd pfet_06v0 ad=1.98p pd=7.2u as=1.98p ps=7.2u w=6.6u l=0.6u
X534 a_4932_108# znp a_4908_108# avss nfet_06v0 ad=1.98p pd=7.2u as=1.98p ps=7.2u w=6.6u l=0.6u
X535 avdd zpm o avdd pfet_06v0 ad=1.98p pd=7.2u as=1.98p ps=7.2u w=6.6u l=0.6u
X536 a_5076_276# znp znm avss nfet_06v0 ad=1.98p pd=7.2u as=1.98p ps=7.2u w=6.6u l=0.6u
X537 bpa_ bpb bpb avdd pfet_06v0 ad=1.98p pd=7.2u as=1.98p ps=7.2u w=6.6u l=0.6u
X538 avdd en a_6324_816# avdd pfet_06v0 ad=3.96p pd=14.4u as=1.98p ps=7.2u w=6.6u l=0.6u
X539 a_5364_276# bnb znm avss nfet_06v0 ad=1.98p pd=7.2u as=1.98p ps=7.2u w=6.6u l=0.6u
X540 bpa_ bpb bpb avdd pfet_06v0 ad=1.98p pd=7.2u as=1.98p ps=7.2u w=6.6u l=0.6u
X541 xp1 inp ynm avdd pfet_06v0 ad=1.98p pd=7.2u as=1.98p ps=7.2u w=6.6u l=0.6u
X542 a_5652_276# znp znm avss nfet_06v0 ad=1.98p pd=7.2u as=1.98p ps=7.2u w=6.6u l=0.6u
X543 ypp zpp a_2772_984# avdd pfet_06v0 ad=1.98p pd=7.2u as=1.98p ps=7.2u w=6.6u l=0.6u
X544 zpm bpb znm avdd pfet_06v0 ad=1.98p pd=7.2u as=1.98p ps=7.2u w=6.6u l=0.6u
X545 a_4260_108# bna a_4236_108# avss nfet_06v0 ad=1.98p pd=7.2u as=1.98p ps=7.2u w=6.6u l=0.6u
X546 a_4548_108# bnb a_4332_108# avss nfet_06v0 ad=1.98p pd=7.2u as=1.98p ps=7.2u w=6.6u l=0.6u
X547 a_4836_108# znp avss avss nfet_06v0 ad=1.98p pd=7.2u as=1.98p ps=7.2u w=6.6u l=0.6u
X548 xn inp a_3060_108# avss nfet_06v0 ad=1.98p pd=7.2u as=1.98p ps=7.2u w=6.6u l=0.6u
X549 a_1980_816# bpa a_1956_816# avdd pfet_06v0 ad=1.98p pd=7.2u as=1.98p ps=7.2u w=6.6u l=0.6u
X550 a_3372_108# bna a_3348_108# avss nfet_06v0 ad=1.98p pd=7.2u as=1.98p ps=7.2u w=6.6u l=0.6u
X551 a_5556_276# znp znm avss nfet_06v0 ad=1.98p pd=7.2u as=1.98p ps=7.2u w=6.6u l=0.6u
X552 a_5268_276# bnb znm avss nfet_06v0 ad=1.98p pd=7.2u as=1.98p ps=7.2u w=6.6u l=0.6u
X553 avdd bpa a_2676_984# avdd pfet_06v0 ad=1.98p pd=7.2u as=1.98p ps=7.2u w=6.6u l=0.6u
X554 zpm bpb znm avdd pfet_06v0 ad=1.98p pd=7.2u as=1.98p ps=7.2u w=6.6u l=0.6u
X555 a_5844_276# znp a_5820_276# avss nfet_06v0 ad=1.98p pd=7.2u as=1.98p ps=7.2u w=6.6u l=0.6u
X556 ypm zpp a_2964_984# avdd pfet_06v0 ad=1.98p pd=7.2u as=1.98p ps=7.2u w=6.6u l=0.6u
X557 a_5364_816# zpp avdd avdd pfet_06v0 ad=1.98p pd=7.2u as=1.98p ps=7.2u w=6.6u l=0.6u
X558 a_4092_276# znp a_4068_276# avss nfet_06v0 ad=1.98p pd=7.2u as=1.98p ps=7.2u w=6.6u l=0.6u
X559 zpm bpb znm avdd pfet_06v0 ad=1.98p pd=7.2u as=1.98p ps=7.2u w=6.6u l=0.6u
X560 a_4740_108# bna a_4716_108# avss nfet_06v0 ad=1.98p pd=7.2u as=1.98p ps=7.2u w=6.6u l=0.6u
X561 xn inm a_3252_108# avss nfet_06v0 ad=1.98p pd=7.2u as=1.98p ps=7.2u w=6.6u l=0.6u
X562 a_3564_108# znp a_3540_108# avss nfet_06v0 ad=1.98p pd=7.2u as=1.98p ps=7.2u w=6.6u l=0.6u
X563 a_132_108# en avss avss nfet_06v0 ad=1.98p pd=7.2u as=3.96p ps=14.4u w=6.6u l=0.6u
X564 o zpm avdd avdd pfet_06v0 ad=1.98p pd=7.2u as=1.98p ps=7.2u w=6.6u l=0.6u
X565 ynp znp a_3828_108# avss nfet_06v0 ad=1.98p pd=7.2u as=1.98p ps=7.2u w=6.6u l=0.6u
X566 a_5460_276# bnb znm avss nfet_06v0 ad=1.98p pd=7.2u as=1.98p ps=7.2u w=6.6u l=0.6u
X567 a_5748_276# znp a_5724_276# avss nfet_06v0 ad=1.98p pd=7.2u as=1.98p ps=7.2u w=6.6u l=0.6u
X568 a_5268_816# zpp ypm avdd pfet_06v0 ad=1.98p pd=7.2u as=1.98p ps=7.2u w=6.6u l=0.6u
X569 zpm bpb znm avdd pfet_06v0 ad=1.98p pd=7.2u as=1.98p ps=7.2u w=6.6u l=0.6u
X570 a_4284_276# bna a_4260_276# avss nfet_06v0 ad=1.98p pd=7.2u as=1.98p ps=7.2u w=6.6u l=0.6u
X571 a_4092_816# bpa a_4068_816# avdd pfet_06v0 ad=1.98p pd=7.2u as=1.98p ps=7.2u w=6.6u l=0.6u
X572 a_5844_816# zpp a_5820_816# avdd pfet_06v0 ad=1.98p pd=7.2u as=1.98p ps=7.2u w=6.6u l=0.6u
X573 zpp bnb a_4548_276# avss nfet_06v0 ad=1.98p pd=7.2u as=1.98p ps=7.2u w=6.6u l=0.6u
X574 a_2004_984# bpa a_1980_984# avdd pfet_06v0 ad=1.98p pd=7.2u as=1.98p ps=7.2u w=6.6u l=0.6u
X575 xn inp a_3156_108# avss nfet_06v0 ad=1.98p pd=7.2u as=1.98p ps=7.2u w=6.6u l=0.6u
X576 ynp znp a_3732_108# avss nfet_06v0 ad=1.98p pd=7.2u as=1.98p ps=7.2u w=6.6u l=0.6u
X577 avss bna a_3444_108# avss nfet_06v0 ad=1.98p pd=7.2u as=1.98p ps=7.2u w=6.6u l=0.6u
X578 a_324_108# en bna_ avss nfet_06v0 ad=1.98p pd=7.2u as=1.98p ps=7.2u w=6.6u l=0.6u
X579 a_6276_984# en avdd avdd pfet_06v0 ad=1.98p pd=7.2u as=1.98p ps=7.2u w=6.6u l=0.6u
X580 a_2292_108# znp a_2268_108# avss nfet_06v0 ad=1.98p pd=7.2u as=1.98p ps=7.2u w=6.6u l=0.6u
X581 a_612_108# bnb bna_ avss nfet_06v0 ad=1.98p pd=7.2u as=1.98p ps=7.2u w=6.6u l=0.6u
X582 a_5940_276# znm o avss nfet_06v0 ad=1.98p pd=7.2u as=1.98p ps=7.2u w=6.6u l=0.6u
X583 a_4188_276# bna a_4164_276# avss nfet_06v0 ad=1.98p pd=7.2u as=1.98p ps=7.2u w=6.6u l=0.6u
X584 zpm zpp ypm avdd pfet_06v0 ad=1.98p pd=7.2u as=1.98p ps=7.2u w=6.6u l=0.6u
X585 zpp bnb a_4452_276# avss nfet_06v0 ad=1.98p pd=7.2u as=1.98p ps=7.2u w=6.6u l=0.6u
X586 zpm zpp ypm avdd pfet_06v0 ad=1.98p pd=7.2u as=1.98p ps=7.2u w=6.6u l=0.6u
X587 a_4764_276# bna a_4740_276# avss nfet_06v0 ad=1.98p pd=7.2u as=1.98p ps=7.2u w=6.6u l=0.6u
X588 a_1560_811# a_1560_811# a_1884_984# avdd pfet_06v0 ad=1.98p pd=7.2u as=1.98p ps=7.2u w=6.6u l=0.6u
X589 ypp zpp zpp avdd pfet_06v0 ad=1.98p pd=7.2u as=1.98p ps=7.2u w=6.6u l=0.6u
X590 ypp zpp a_4548_816# avdd pfet_06v0 ad=1.98p pd=7.2u as=1.98p ps=7.2u w=6.6u l=0.6u
X591 ynp znp a_3636_108# avss nfet_06v0 ad=1.98p pd=7.2u as=1.98p ps=7.2u w=6.6u l=0.6u
X592 a_228_108# enb avss avss nfet_06v0 ad=1.98p pd=7.2u as=1.98p ps=7.2u w=6.6u l=0.6u
X593 o zpm avdd avdd pfet_06v0 ad=1.98p pd=7.2u as=1.98p ps=7.2u w=6.6u l=0.6u
X594 ynp znp a_3924_108# avss nfet_06v0 ad=1.98p pd=7.2u as=1.98p ps=7.2u w=6.6u l=0.6u
X595 a_2196_108# znp a_2172_108# avss nfet_06v0 ad=1.98p pd=7.2u as=1.98p ps=7.2u w=6.6u l=0.6u
X596 a_516_108# bna a_492_108# avss nfet_06v0 ad=1.98p pd=7.2u as=1.98p ps=7.2u w=6.6u l=0.6u
X597 a_2772_108# bna a_2748_108# avss nfet_06v0 ad=1.98p pd=7.2u as=1.98p ps=7.2u w=6.6u l=0.6u
X598 a_2484_108# znp a_2460_108# avss nfet_06v0 ad=1.98p pd=7.2u as=1.98p ps=7.2u w=6.6u l=0.6u
X599 a_5292_984# zpp a_5268_984# avdd pfet_06v0 ad=1.98p pd=7.2u as=1.98p ps=7.2u w=6.6u l=0.6u
X600 a_4668_276# bna a_4644_276# avss nfet_06v0 ad=1.98p pd=7.2u as=1.98p ps=7.2u w=6.6u l=0.6u
X601 zpp bnb a_4356_276# avss nfet_06v0 ad=1.98p pd=7.2u as=1.98p ps=7.2u w=6.6u l=0.6u
X602 a_4188_816# zpp a_4164_816# avdd pfet_06v0 ad=1.98p pd=7.2u as=1.98p ps=7.2u w=6.6u l=0.6u
X603 o zpm avdd avdd pfet_06v0 ad=1.98p pd=7.2u as=1.98p ps=7.2u w=6.6u l=0.6u
X604 a_3204_276# inm xn avss nfet_06v0 ad=1.98p pd=7.2u as=1.98p ps=7.2u w=6.6u l=0.6u
X605 a_4956_276# znp a_4932_276# avss nfet_06v0 ad=1.98p pd=7.2u as=1.98p ps=7.2u w=6.6u l=0.6u
X606 avdd zpp a_4452_816# avdd pfet_06v0 ad=1.98p pd=7.2u as=1.98p ps=7.2u w=6.6u l=0.6u
X607 a_3492_276# znp avss avss nfet_06v0 ad=1.98p pd=7.2u as=1.98p ps=7.2u w=6.6u l=0.6u
X608 a_4764_816# zpp a_4740_816# avdd pfet_06v0 ad=1.98p pd=7.2u as=1.98p ps=7.2u w=6.6u l=0.6u
X609 a_2100_108# znp a_2076_108# avss nfet_06v0 ad=1.98p pd=7.2u as=1.98p ps=7.2u w=6.6u l=0.6u
X610 a_420_108# bna avss avss nfet_06v0 ad=1.98p pd=7.2u as=1.98p ps=7.2u w=6.6u l=0.6u
X611 a_2388_108# znp a_2364_108# avss nfet_06v0 ad=1.98p pd=7.2u as=1.98p ps=7.2u w=6.6u l=0.6u
X612 a_2676_108# znp a_2652_108# avss nfet_06v0 ad=1.98p pd=7.2u as=1.98p ps=7.2u w=6.6u l=0.6u
X613 ypm zpp zpm avdd pfet_06v0 ad=1.98p pd=7.2u as=1.98p ps=7.2u w=6.6u l=0.6u
X614 a_2964_108# inm ypp avss nfet_06v0 ad=1.98p pd=7.2u as=1.98p ps=7.2u w=6.6u l=0.6u
X615 ypm zpp zpm avdd pfet_06v0 ad=1.98p pd=7.2u as=1.98p ps=7.2u w=6.6u l=0.6u
X616 ypm zpp zpm avdd pfet_06v0 ad=1.98p pd=7.2u as=1.98p ps=7.2u w=6.6u l=0.6u
X617 a_3108_276# inp xn avss nfet_06v0 ad=1.98p pd=7.2u as=1.98p ps=7.2u w=6.6u l=0.6u
X618 a_4860_276# znp a_4836_276# avss nfet_06v0 ad=1.98p pd=7.2u as=1.98p ps=7.2u w=6.6u l=0.6u
X619 bpa_ bpb bpb avdd pfet_06v0 ad=1.98p pd=7.2u as=1.98p ps=7.2u w=6.6u l=0.6u
X620 ypp zpp zpp avdd pfet_06v0 ad=1.98p pd=7.2u as=1.98p ps=7.2u w=6.6u l=0.6u
X621 ypp zpp zpp avdd pfet_06v0 ad=1.98p pd=7.2u as=1.98p ps=7.2u w=6.6u l=0.6u
X622 a_3684_276# znp ynp avss nfet_06v0 ad=1.98p pd=7.2u as=1.98p ps=7.2u w=6.6u l=0.6u
X623 a_3396_276# bna a_3372_276# avss nfet_06v0 ad=1.98p pd=7.2u as=1.98p ps=7.2u w=6.6u l=0.6u
X624 a_3204_816# zpp ypm avdd pfet_06v0 ad=1.98p pd=7.2u as=1.98p ps=7.2u w=6.6u l=0.6u
X625 ypm zpp zpm avdd pfet_06v0 ad=1.98p pd=7.2u as=1.98p ps=7.2u w=6.6u l=0.6u
X626 bna enb a_228_276# avss nfet_06v0 ad=1.98p pd=7.2u as=1.98p ps=7.2u w=6.6u l=0.6u
X627 a_3972_276# znp ynp avss nfet_06v0 ad=1.98p pd=7.2u as=1.98p ps=7.2u w=6.6u l=0.6u
X628 a_3492_816# bpa avdd avdd pfet_06v0 ad=1.98p pd=7.2u as=1.98p ps=7.2u w=6.6u l=0.6u
X629 a_2580_108# znp a_2556_108# avss nfet_06v0 ad=1.98p pd=7.2u as=1.98p ps=7.2u w=6.6u l=0.6u
X630 znm bpb zpm avdd pfet_06v0 ad=1.98p pd=7.2u as=1.98p ps=7.2u w=6.6u l=0.6u
X631 a_2868_108# bna a_2844_108# avss nfet_06v0 ad=1.98p pd=7.2u as=1.98p ps=7.2u w=6.6u l=0.6u
X632 a_5388_984# zpp a_5364_984# avdd pfet_06v0 ad=1.98p pd=7.2u as=1.98p ps=7.2u w=6.6u l=0.6u
X633 a_1404_108# bna a_1380_108# avss nfet_06v0 ad=1.98p pd=7.2u as=1.98p ps=7.2u w=6.6u l=0.6u
X634 znm bpb zpm avdd pfet_06v0 ad=1.98p pd=7.2u as=1.98p ps=7.2u w=6.6u l=0.6u
X635 a_1692_108# bna a_1668_108# avss nfet_06v0 ad=1.98p pd=7.2u as=1.98p ps=7.2u w=6.6u l=0.6u
X636 bpa_ bpb bpb avdd pfet_06v0 ad=1.98p pd=7.2u as=1.98p ps=7.2u w=6.6u l=0.6u
X637 avdd zpm o avdd pfet_06v0 ad=1.98p pd=7.2u as=1.98p ps=7.2u w=6.6u l=0.6u
X638 a_3300_276# bna xn avss nfet_06v0 ad=1.98p pd=7.2u as=1.98p ps=7.2u w=6.6u l=0.6u
X639 enb en a_132_276# avss nfet_06v0 ad=1.98p pd=7.2u as=1.98p ps=7.2u w=6.6u l=0.6u
X640 a_3588_276# znp a_3564_276# avss nfet_06v0 ad=1.98p pd=7.2u as=1.98p ps=7.2u w=6.6u l=0.6u
X641 a_3108_816# zpp avdd avdd pfet_06v0 ad=1.98p pd=7.2u as=1.98p ps=7.2u w=6.6u l=0.6u
X642 a_4860_816# zpp a_4836_816# avdd pfet_06v0 ad=1.98p pd=7.2u as=1.98p ps=7.2u w=6.6u l=0.6u
X643 a_444_276# bna a_420_276# avss nfet_06v0 ad=1.98p pd=7.2u as=1.98p ps=7.2u w=6.6u l=0.6u
X644 avss znm a_6228_108# avss nfet_06v0 ad=1.98p pd=7.2u as=1.98p ps=7.2u w=6.6u l=0.6u
X645 a_3876_276# znp ynp avss nfet_06v0 ad=1.98p pd=7.2u as=1.98p ps=7.2u w=6.6u l=0.6u
X646 bpa en a_228_816# avdd pfet_06v0 ad=1.98p pd=7.2u as=1.98p ps=7.2u w=6.6u l=0.6u
X647 a_3396_816# zpp ypp avdd pfet_06v0 ad=1.98p pd=7.2u as=1.98p ps=7.2u w=6.6u l=0.6u
X648 znp bpb a_3660_816# avdd pfet_06v0 ad=1.98p pd=7.2u as=1.98p ps=7.2u w=6.6u l=0.6u
X649 bnb bnb a_708_276# avss nfet_06v0 ad=1.98p pd=7.2u as=1.98p ps=7.2u w=6.6u l=0.6u
X650 znp bpb a_3900_816# avdd pfet_06v0 ad=1.98p pd=7.2u as=1.98p ps=7.2u w=6.6u l=0.6u
X651 znm bpb zpm avdd pfet_06v0 ad=1.98p pd=7.2u as=1.98p ps=7.2u w=6.6u l=0.6u
X652 bnb bnb a_1284_108# avss nfet_06v0 ad=1.98p pd=7.2u as=1.98p ps=7.2u w=6.6u l=0.6u
X653 avdd zpp a_5844_984# avdd pfet_06v0 ad=1.98p pd=7.2u as=1.98p ps=7.2u w=6.6u l=0.6u
X654 a_1884_108# bna a_1860_108# avss nfet_06v0 ad=1.98p pd=7.2u as=1.98p ps=7.2u w=6.6u l=0.6u
X655 a_1596_108# bna a_1572_108# avss nfet_06v0 ad=1.98p pd=7.2u as=1.98p ps=7.2u w=6.6u l=0.6u
X656 a_1020_984# bpa a_996_984# avdd pfet_06v0 ad=1.98p pd=7.2u as=1.98p ps=7.2u w=6.6u l=0.6u
X657 a_4404_984# zpp ypp avdd pfet_06v0 ad=1.98p pd=7.2u as=1.98p ps=7.2u w=6.6u l=0.6u
X658 zpp zpp ypp avdd pfet_06v0 ad=1.98p pd=7.2u as=1.98p ps=7.2u w=6.6u l=0.6u
X659 bna en a_324_276# avss nfet_06v0 ad=1.98p pd=7.2u as=1.98p ps=7.2u w=6.6u l=0.6u
X660 avss znm a_6132_108# avss nfet_06v0 ad=1.98p pd=7.2u as=1.98p ps=7.2u w=6.6u l=0.6u
X661 a_3780_276# znp ynp avss nfet_06v0 ad=1.98p pd=7.2u as=1.98p ps=7.2u w=6.6u l=0.6u
X662 a_3300_816# zpp avdd avdd pfet_06v0 ad=1.98p pd=7.2u as=1.98p ps=7.2u w=6.6u l=0.6u
X663 bnb bnb a_612_276# avss nfet_06v0 ad=1.98p pd=7.2u as=1.98p ps=7.2u w=6.6u l=0.6u
X664 enb en a_132_816# avdd pfet_06v0 ad=1.98p pd=7.2u as=1.98p ps=7.2u w=6.6u l=0.6u
X665 znp bpb a_3564_816# avdd pfet_06v0 ad=1.98p pd=7.2u as=1.98p ps=7.2u w=6.6u l=0.6u
X666 bnb bnb a_900_276# avss nfet_06v0 ad=1.98p pd=7.2u as=1.98p ps=7.2u w=6.6u l=0.6u
X667 a_2604_276# znp a_2580_276# avss nfet_06v0 ad=1.98p pd=7.2u as=1.98p ps=7.2u w=6.6u l=0.6u
X668 a_444_816# bpa a_420_816# avdd pfet_06v0 ad=1.98p pd=7.2u as=1.98p ps=7.2u w=6.6u l=0.6u
X669 bpa_ bpb bpb avdd pfet_06v0 ad=1.98p pd=7.2u as=1.98p ps=7.2u w=6.6u l=0.6u
X670 a_3876_816# bpa a_3852_816# avdd pfet_06v0 ad=1.98p pd=7.2u as=1.98p ps=7.2u w=6.6u l=0.6u
X671 xn bna a_2868_276# avss nfet_06v0 ad=1.98p pd=7.2u as=1.98p ps=7.2u w=6.6u l=0.6u
X672 a_1500_108# bna a_1476_108# avss nfet_06v0 ad=1.98p pd=7.2u as=1.98p ps=7.2u w=6.6u l=0.6u
X673 a_1788_108# bna a_1764_108# avss nfet_06v0 ad=1.98p pd=7.2u as=1.98p ps=7.2u w=6.6u l=0.6u
X674 zpp zpp ypp avdd pfet_06v0 ad=1.98p pd=7.2u as=1.98p ps=7.2u w=6.6u l=0.6u
X675 zpp zpp ypp avdd pfet_06v0 ad=1.98p pd=7.2u as=1.98p ps=7.2u w=6.6u l=0.6u
X676 a_4884_984# zpp a_4860_984# avdd pfet_06v0 ad=1.98p pd=7.2u as=1.98p ps=7.2u w=6.6u l=0.6u
X677 avss znm a_6036_108# avss nfet_06v0 ad=1.98p pd=7.2u as=1.98p ps=7.2u w=6.6u l=0.6u
X678 avss enb a_6324_108# avss nfet_06v0 ad=3.96p pd=14.4u as=1.98p ps=7.2u w=6.6u l=0.6u
X679 a_540_276# bna a_516_276# avss nfet_06v0 ad=1.98p pd=7.2u as=1.98p ps=7.2u w=6.6u l=0.6u
X680 bnb bnb a_804_276# avss nfet_06v0 ad=1.98p pd=7.2u as=1.98p ps=7.2u w=6.6u l=0.6u
X681 bpa enb a_324_816# avdd pfet_06v0 ad=1.98p pd=7.2u as=1.98p ps=7.2u w=6.6u l=0.6u
X682 a_3780_816# bpa a_3756_816# avdd pfet_06v0 ad=1.98p pd=7.2u as=1.98p ps=7.2u w=6.6u l=0.6u
X683 ynm znp a_2484_276# avss nfet_06v0 ad=1.98p pd=7.2u as=1.98p ps=7.2u w=6.6u l=0.6u
X684 a_2796_276# bna a_2772_276# avss nfet_06v0 ad=1.98p pd=7.2u as=1.98p ps=7.2u w=6.6u l=0.6u
X685 a_5172_108# bnb znm avss nfet_06v0 ad=1.98p pd=7.2u as=1.98p ps=7.2u w=6.6u l=0.6u
X686 bpa_ bpb bpb avdd pfet_06v0 ad=1.98p pd=7.2u as=1.98p ps=7.2u w=6.6u l=0.6u
X687 a_924_816# bpa a_900_816# avdd pfet_06v0 ad=1.98p pd=7.2u as=1.98p ps=7.2u w=6.6u l=0.6u
X688 xp1 inm ynp avdd pfet_06v0 ad=1.98p pd=7.2u as=1.98p ps=7.2u w=6.6u l=0.6u
X689 avdd zpp a_2868_816# avdd pfet_06v0 ad=1.98p pd=7.2u as=1.98p ps=7.2u w=6.6u l=0.6u
X690 a_1980_108# znp a_1956_108# avss nfet_06v0 ad=1.98p pd=7.2u as=1.98p ps=7.2u w=6.6u l=0.6u
X691 a_4500_984# zpp avdd avdd pfet_06v0 ad=1.98p pd=7.2u as=1.98p ps=7.2u w=6.6u l=0.6u
X692 a_4788_984# zpp a_4764_984# avdd pfet_06v0 ad=1.98p pd=7.2u as=1.98p ps=7.2u w=6.6u l=0.6u
X693 avss znp a_2676_276# avss nfet_06v0 ad=1.98p pd=7.2u as=1.98p ps=7.2u w=6.6u l=0.6u
X694 a_5076_108# znp znm avss nfet_06v0 ad=1.98p pd=7.2u as=1.98p ps=7.2u w=6.6u l=0.6u
X695 bpa_ bpb bpb avdd pfet_06v0 ad=1.98p pd=7.2u as=1.98p ps=7.2u w=6.6u l=0.6u
X696 bpa_ bpb bpb avdd pfet_06v0 ad=1.98p pd=7.2u as=1.98p ps=7.2u w=6.6u l=0.6u
X697 xn inm a_2964_276# avss nfet_06v0 ad=1.98p pd=7.2u as=1.98p ps=7.2u w=6.6u l=0.6u
X698 a_5364_108# bnb znm avss nfet_06v0 ad=1.98p pd=7.2u as=1.98p ps=7.2u w=6.6u l=0.6u
X699 a_5652_108# znp znm avss nfet_06v0 ad=1.98p pd=7.2u as=1.98p ps=7.2u w=6.6u l=0.6u
X700 xp1 inp ynm avdd pfet_06v0 ad=1.98p pd=7.2u as=1.98p ps=7.2u w=6.6u l=0.6u
X701 ypp zpp a_2772_816# avdd pfet_06v0 ad=1.98p pd=7.2u as=1.98p ps=7.2u w=6.6u l=0.6u
X702 a_6084_276# znm avss avss nfet_06v0 ad=1.98p pd=7.2u as=1.98p ps=7.2u w=6.6u l=0.6u
X703 zpm zpp ypm avdd pfet_06v0 ad=1.98p pd=7.2u as=1.98p ps=7.2u w=6.6u l=0.6u
X704 a_372_984# en bpa avdd pfet_06v0 ad=1.98p pd=7.2u as=1.98p ps=7.2u w=6.6u l=0.6u
X705 avdd bpa a_3780_984# avdd pfet_06v0 ad=1.98p pd=7.2u as=1.98p ps=7.2u w=6.6u l=0.6u
X706 a_5268_108# bnb znm avss nfet_06v0 ad=1.98p pd=7.2u as=1.98p ps=7.2u w=6.6u l=0.6u
X707 a_5556_108# znp znm avss nfet_06v0 ad=1.98p pd=7.2u as=1.98p ps=7.2u w=6.6u l=0.6u
X708 avdd bpa a_2676_816# avdd pfet_06v0 ad=1.98p pd=7.2u as=1.98p ps=7.2u w=6.6u l=0.6u
X709 a_4092_108# znp a_4068_108# avss nfet_06v0 ad=1.98p pd=7.2u as=1.98p ps=7.2u w=6.6u l=0.6u
X710 a_5844_108# znp a_5820_108# avss nfet_06v0 ad=1.98p pd=7.2u as=1.98p ps=7.2u w=6.6u l=0.6u
X711 ypm zpp a_2964_816# avdd pfet_06v0 ad=1.98p pd=7.2u as=1.98p ps=7.2u w=6.6u l=0.6u
X712 a_2004_276# znp a_1980_276# avss nfet_06v0 ad=1.98p pd=7.2u as=1.98p ps=7.2u w=6.6u l=0.6u
X713 a_6276_276# enb avss avss nfet_06v0 ad=1.98p pd=7.2u as=1.98p ps=7.2u w=6.6u l=0.6u
X714 a_276_984# enb bpa avdd pfet_06v0 ad=1.98p pd=7.2u as=1.98p ps=7.2u w=6.6u l=0.6u
X715 a_3660_816# bpb znp avdd pfet_06v0 ad=1.98p pd=7.2u as=1.98p ps=7.2u w=6.6u l=0.6u
X716 o zpm avdd avdd pfet_06v0 ad=1.98p pd=7.2u as=1.98p ps=7.2u w=6.6u l=0.6u
X717 bpb bpb bpa_ avdd pfet_06v0 ad=1.98p pd=7.2u as=1.98p ps=7.2u w=6.6u l=0.6u
X718 a_3996_816# bpb znp avdd pfet_06v0 ad=1.98p pd=7.2u as=1.98p ps=7.2u w=6.6u l=0.6u
X719 a_5460_108# bnb znm avss nfet_06v0 ad=1.98p pd=7.2u as=1.98p ps=7.2u w=6.6u l=0.6u
X720 bpb bpb bpa_ avdd pfet_06v0 ad=1.98p pd=7.2u as=1.98p ps=7.2u w=6.6u l=0.6u
X721 a_5748_108# znp a_5724_108# avss nfet_06v0 ad=1.98p pd=7.2u as=1.98p ps=7.2u w=6.6u l=0.6u
X722 a_1908_276# bna a_1884_276# avss nfet_06v0 ad=1.98p pd=7.2u as=1.98p ps=7.2u w=6.6u l=0.6u
X723 a_4284_108# bna a_4260_108# avss nfet_06v0 ad=1.98p pd=7.2u as=1.98p ps=7.2u w=6.6u l=0.6u
X724 zpp bnb a_4548_108# avss nfet_06v0 ad=1.98p pd=7.2u as=1.98p ps=7.2u w=6.6u l=0.6u
X725 a_6180_276# znm avss avss nfet_06v0 ad=1.98p pd=7.2u as=1.98p ps=7.2u w=6.6u l=0.6u
X726 a_2004_816# bpa a_1980_816# avdd pfet_06v0 ad=1.98p pd=7.2u as=1.98p ps=7.2u w=6.6u l=0.6u
X727 a_180_984# en enb avdd pfet_06v0 ad=1.98p pd=7.2u as=1.98p ps=7.2u w=6.6u l=0.6u
X728 a_468_984# bpa a_444_984# avdd pfet_06v0 ad=1.98p pd=7.2u as=1.98p ps=7.2u w=6.6u l=0.6u
X729 bpb bpb bpa_ avdd pfet_06v0 ad=1.98p pd=7.2u as=1.98p ps=7.2u w=6.6u l=0.6u
X730 a_3900_816# bpa a_3876_984# avdd pfet_06v0 ad=1.98p pd=7.2u as=1.98p ps=7.2u w=6.6u l=0.6u
X731 a_6276_816# en avdd avdd pfet_06v0 ad=1.98p pd=7.2u as=1.98p ps=7.2u w=6.6u l=0.6u
X732 zpm bnb a_5268_276# avss nfet_06v0 ad=1.98p pd=7.2u as=1.98p ps=7.2u w=6.6u l=0.6u
X733 a_5940_108# znm o avss nfet_06v0 ad=1.98p pd=7.2u as=1.98p ps=7.2u w=6.6u l=0.6u
X734 a_4188_108# bna a_4164_108# avss nfet_06v0 ad=1.98p pd=7.2u as=1.98p ps=7.2u w=6.6u l=0.6u
X735 zpp bnb a_4452_108# avss nfet_06v0 ad=1.98p pd=7.2u as=1.98p ps=7.2u w=6.6u l=0.6u
X736 a_4764_108# bna a_4740_108# avss nfet_06v0 ad=1.98p pd=7.2u as=1.98p ps=7.2u w=6.6u l=0.6u
X737 a_1560_811# a_1560_811# a_1884_816# avdd pfet_06v0 ad=1.98p pd=7.2u as=1.98p ps=7.2u w=6.6u l=0.6u
X738 a_3012_984# zpp ypm avdd pfet_06v0 ad=1.98p pd=7.2u as=1.98p ps=7.2u w=6.6u l=0.6u
X739 o zpm avdd avdd pfet_06v0 ad=1.98p pd=7.2u as=1.98p ps=7.2u w=6.6u l=0.6u
X740 zpm bnb a_5172_276# avss nfet_06v0 ad=1.98p pd=7.2u as=1.98p ps=7.2u w=6.6u l=0.6u
X741 bpb bpb bpa_ avdd pfet_06v0 ad=1.98p pd=7.2u as=1.98p ps=7.2u w=6.6u l=0.6u
X742 zpm bnb a_5460_276# avss nfet_06v0 ad=1.98p pd=7.2u as=1.98p ps=7.2u w=6.6u l=0.6u
X743 a_948_984# bpa a_924_984# avdd pfet_06v0 ad=1.98p pd=7.2u as=1.98p ps=7.2u w=6.6u l=0.6u
X744 a_5772_276# znp a_5748_276# avss nfet_06v0 ad=1.98p pd=7.2u as=1.98p ps=7.2u w=6.6u l=0.6u
X745 a_5292_816# zpp a_5268_816# avdd pfet_06v0 ad=1.98p pd=7.2u as=1.98p ps=7.2u w=6.6u l=0.6u
X746 bnb bnb a_1188_276# avss nfet_06v0 ad=1.98p pd=7.2u as=1.98p ps=7.2u w=6.6u l=0.6u
X747 zpp bnb a_4356_108# avss nfet_06v0 ad=1.98p pd=7.2u as=1.98p ps=7.2u w=6.6u l=0.6u
X748 a_4668_108# bna a_4644_108# avss nfet_06v0 ad=1.98p pd=7.2u as=1.98p ps=7.2u w=6.6u l=0.6u
X749 a_4956_108# znp a_4932_108# avss nfet_06v0 ad=1.98p pd=7.2u as=1.98p ps=7.2u w=6.6u l=0.6u
X750 a_3204_108# inm xn avss nfet_06v0 ad=1.98p pd=7.2u as=1.98p ps=7.2u w=6.6u l=0.6u
X751 a_3492_108# znp avss avss nfet_06v0 ad=1.98p pd=7.2u as=1.98p ps=7.2u w=6.6u l=0.6u
X752 ynm znp a_5076_276# avss nfet_06v0 ad=1.98p pd=7.2u as=1.98p ps=7.2u w=6.6u l=0.6u
X753 ynm znp a_5652_276# avss nfet_06v0 ad=1.98p pd=7.2u as=1.98p ps=7.2u w=6.6u l=0.6u
X754 zpm bnb a_5364_276# avss nfet_06v0 ad=1.98p pd=7.2u as=1.98p ps=7.2u w=6.6u l=0.6u
X755 ypm zpp zpm avdd pfet_06v0 ad=1.98p pd=7.2u as=1.98p ps=7.2u w=6.6u l=0.6u
X756 avss znm a_5940_276# avss nfet_06v0 ad=1.98p pd=7.2u as=1.98p ps=7.2u w=6.6u l=0.6u
X757 ypm zpp zpm avdd pfet_06v0 ad=1.98p pd=7.2u as=1.98p ps=7.2u w=6.6u l=0.6u
X758 bnb bnb a_1092_276# avss nfet_06v0 ad=1.98p pd=7.2u as=1.98p ps=7.2u w=6.6u l=0.6u
X759 ypm zpp zpm avdd pfet_06v0 ad=1.98p pd=7.2u as=1.98p ps=7.2u w=6.6u l=0.6u
X760 a_4860_108# znp a_4836_108# avss nfet_06v0 ad=1.98p pd=7.2u as=1.98p ps=7.2u w=6.6u l=0.6u
X761 a_3108_108# inp xn avss nfet_06v0 ad=1.98p pd=7.2u as=1.98p ps=7.2u w=6.6u l=0.6u
X762 bpa_ bpb bpb avdd pfet_06v0 ad=1.98p pd=7.2u as=1.98p ps=7.2u w=6.6u l=0.6u
X763 a_3396_108# bna a_3372_108# avss nfet_06v0 ad=1.98p pd=7.2u as=1.98p ps=7.2u w=6.6u l=0.6u
X764 a_3684_108# znp ynp avss nfet_06v0 ad=1.98p pd=7.2u as=1.98p ps=7.2u w=6.6u l=0.6u
X765 bna enb a_228_108# avss nfet_06v0 ad=1.98p pd=7.2u as=1.98p ps=7.2u w=6.6u l=0.6u
X766 avdd zpm o avdd pfet_06v0 ad=1.98p pd=7.2u as=1.98p ps=7.2u w=6.6u l=0.6u
X767 a_3972_108# znp ynp avss nfet_06v0 ad=1.98p pd=7.2u as=1.98p ps=7.2u w=6.6u l=0.6u
X768 ynm znp a_5556_276# avss nfet_06v0 ad=1.98p pd=7.2u as=1.98p ps=7.2u w=6.6u l=0.6u
X769 znm bpb zpm avdd pfet_06v0 ad=1.98p pd=7.2u as=1.98p ps=7.2u w=6.6u l=0.6u
X770 a_5388_816# zpp a_5364_816# avdd pfet_06v0 ad=1.98p pd=7.2u as=1.98p ps=7.2u w=6.6u l=0.6u
X771 bnb bnb a_996_276# avss nfet_06v0 ad=1.98p pd=7.2u as=1.98p ps=7.2u w=6.6u l=0.6u
X772 avss znp a_5844_276# avss nfet_06v0 ad=1.98p pd=7.2u as=1.98p ps=7.2u w=6.6u l=0.6u
X773 znm bpb zpm avdd pfet_06v0 ad=1.98p pd=7.2u as=1.98p ps=7.2u w=6.6u l=0.6u
X774 a_4692_276# bna a_4668_276# avss nfet_06v0 ad=1.98p pd=7.2u as=1.98p ps=7.2u w=6.6u l=0.6u
X775 a_4404_276# bnb zpp avss nfet_06v0 ad=1.98p pd=7.2u as=1.98p ps=7.2u w=6.6u l=0.6u
X776 avdd zpm o avdd pfet_06v0 ad=1.98p pd=7.2u as=1.98p ps=7.2u w=6.6u l=0.6u
X777 bpa_ bpb bpb avdd pfet_06v0 ad=1.98p pd=7.2u as=1.98p ps=7.2u w=6.6u l=0.6u
X778 a_3588_108# znp a_3564_108# avss nfet_06v0 ad=1.98p pd=7.2u as=1.98p ps=7.2u w=6.6u l=0.6u
X779 a_3300_108# bna xn avss nfet_06v0 ad=1.98p pd=7.2u as=1.98p ps=7.2u w=6.6u l=0.6u
X780 enb en a_132_108# avss nfet_06v0 ad=1.98p pd=7.2u as=1.98p ps=7.2u w=6.6u l=0.6u
X781 avdd zpm o avdd pfet_06v0 ad=1.98p pd=7.2u as=1.98p ps=7.2u w=6.6u l=0.6u
X782 a_3876_108# znp ynp avss nfet_06v0 ad=1.98p pd=7.2u as=1.98p ps=7.2u w=6.6u l=0.6u
X783 a_444_108# bna a_420_108# avss nfet_06v0 ad=1.98p pd=7.2u as=1.98p ps=7.2u w=6.6u l=0.6u
X784 bnb bnb a_708_108# avss nfet_06v0 ad=1.98p pd=7.2u as=1.98p ps=7.2u w=6.6u l=0.6u
X785 xp0 inm ynp avdd pfet_06v0 ad=1.98p pd=7.2u as=1.98p ps=7.2u w=6.6u l=0.6u
X786 a_4308_276# bna a_4284_276# avss nfet_06v0 ad=1.98p pd=7.2u as=1.98p ps=7.2u w=6.6u l=0.6u
X787 xp1 bpa a_2388_984# avdd pfet_06v0 ad=1.98p pd=7.2u as=1.98p ps=7.2u w=6.6u l=0.6u
X788 znm bpb zpm avdd pfet_06v0 ad=1.98p pd=7.2u as=1.98p ps=7.2u w=6.6u l=0.6u
X789 a_4596_276# bnb zpp avss nfet_06v0 ad=1.98p pd=7.2u as=1.98p ps=7.2u w=6.6u l=0.6u
X790 a_1020_816# bpa a_996_816# avdd pfet_06v0 ad=1.98p pd=7.2u as=1.98p ps=7.2u w=6.6u l=0.6u
X791 avdd zpp a_5844_816# avdd pfet_06v0 ad=1.98p pd=7.2u as=1.98p ps=7.2u w=6.6u l=0.6u
X792 a_4884_276# znp a_4860_276# avss nfet_06v0 ad=1.98p pd=7.2u as=1.98p ps=7.2u w=6.6u l=0.6u
X793 a_4404_816# zpp ypp avdd pfet_06v0 ad=1.98p pd=7.2u as=1.98p ps=7.2u w=6.6u l=0.6u
X794 zpp zpp ypp avdd pfet_06v0 ad=1.98p pd=7.2u as=1.98p ps=7.2u w=6.6u l=0.6u
X795 a_3780_108# znp ynp avss nfet_06v0 ad=1.98p pd=7.2u as=1.98p ps=7.2u w=6.6u l=0.6u
X796 bna en a_324_108# avss nfet_06v0 ad=1.98p pd=7.2u as=1.98p ps=7.2u w=6.6u l=0.6u
X797 zpm en a_6276_984# avdd pfet_06v0 ad=1.98p pd=7.2u as=1.98p ps=7.2u w=6.6u l=0.6u
X798 a_2604_108# znp a_2580_108# avss nfet_06v0 ad=1.98p pd=7.2u as=1.98p ps=7.2u w=6.6u l=0.6u
X799 bnb bnb a_900_108# avss nfet_06v0 ad=1.98p pd=7.2u as=1.98p ps=7.2u w=6.6u l=0.6u
X800 bnb bnb a_612_108# avss nfet_06v0 ad=1.98p pd=7.2u as=1.98p ps=7.2u w=6.6u l=0.6u
X801 xn bna a_2868_108# avss nfet_06v0 ad=1.98p pd=7.2u as=1.98p ps=7.2u w=6.6u l=0.6u
X802 xp0 bpa a_2004_984# avdd pfet_06v0 ad=1.98p pd=7.2u as=1.98p ps=7.2u w=6.6u l=0.6u
X803 a_4500_276# bnb zpp avss nfet_06v0 ad=1.98p pd=7.2u as=1.98p ps=7.2u w=6.6u l=0.6u
X804 avdd bpa a_2292_984# avdd pfet_06v0 ad=1.98p pd=7.2u as=1.98p ps=7.2u w=6.6u l=0.6u
X805 a_4788_276# bna a_4764_276# avss nfet_06v0 ad=1.98p pd=7.2u as=1.98p ps=7.2u w=6.6u l=0.6u
X806 zpp zpp ypp avdd pfet_06v0 ad=1.98p pd=7.2u as=1.98p ps=7.2u w=6.6u l=0.6u
X807 zpp zpp ypp avdd pfet_06v0 ad=1.98p pd=7.2u as=1.98p ps=7.2u w=6.6u l=0.6u
X808 a_4884_816# zpp a_4860_816# avdd pfet_06v0 ad=1.98p pd=7.2u as=1.98p ps=7.2u w=6.6u l=0.6u
X809 a_540_108# bna a_516_108# avss nfet_06v0 ad=1.98p pd=7.2u as=1.98p ps=7.2u w=6.6u l=0.6u
X810 ynm znp a_2484_108# avss nfet_06v0 ad=1.98p pd=7.2u as=1.98p ps=7.2u w=6.6u l=0.6u
X811 bnb bnb a_804_108# avss nfet_06v0 ad=1.98p pd=7.2u as=1.98p ps=7.2u w=6.6u l=0.6u
X812 a_2796_108# bna a_2772_108# avss nfet_06v0 ad=1.98p pd=7.2u as=1.98p ps=7.2u w=6.6u l=0.6u
X813 xp0 inp ynm avdd pfet_06v0 ad=1.98p pd=7.2u as=1.98p ps=7.2u w=6.6u l=0.6u
X814 zpm bpb znm avdd pfet_06v0 ad=1.98p pd=7.2u as=1.98p ps=7.2u w=6.6u l=0.6u
X815 o zpm avdd avdd pfet_06v0 ad=1.98p pd=7.2u as=1.98p ps=7.2u w=6.6u l=0.6u
X816 a_4980_276# znp a_4956_276# avss nfet_06v0 ad=1.98p pd=7.2u as=1.98p ps=7.2u w=6.6u l=0.6u
X817 a_1044_984# bpa a_1020_984# avdd pfet_06v0 ad=1.98p pd=7.2u as=1.98p ps=7.2u w=6.6u l=0.6u
X818 a_4500_816# zpp avdd avdd pfet_06v0 ad=1.98p pd=7.2u as=1.98p ps=7.2u w=6.6u l=0.6u
X819 bpb bpb bpa_ avdd pfet_06v0 ad=1.98p pd=7.2u as=1.98p ps=7.2u w=6.6u l=0.6u
X820 a_4788_816# zpp a_4764_816# avdd pfet_06v0 ad=1.98p pd=7.2u as=1.98p ps=7.2u w=6.6u l=0.6u
X821 a_372_276# enb bna avss nfet_06v0 ad=1.98p pd=7.2u as=1.98p ps=7.2u w=6.6u l=0.6u
X822 znp znp a_3780_276# avss nfet_06v0 ad=1.98p pd=7.2u as=1.98p ps=7.2u w=6.6u l=0.6u
X823 avss znp a_2676_108# avss nfet_06v0 ad=1.98p pd=7.2u as=1.98p ps=7.2u w=6.6u l=0.6u
X824 xn inm a_2964_108# avss nfet_06v0 ad=1.98p pd=7.2u as=1.98p ps=7.2u w=6.6u l=0.6u
X825 zpm zpp ypm avdd pfet_06v0 ad=1.98p pd=7.2u as=1.98p ps=7.2u w=6.6u l=0.6u
X826 a_5796_984# zpp ypm avdd pfet_06v0 ad=1.98p pd=7.2u as=1.98p ps=7.2u w=6.6u l=0.6u
X827 bpb bpb bpa_ avdd pfet_06v0 ad=1.98p pd=7.2u as=1.98p ps=7.2u w=6.6u l=0.6u
X828 a_1524_984# bpa a_1500_984# avdd pfet_06v0 ad=1.98p pd=7.2u as=1.98p ps=7.2u w=6.6u l=0.6u
X829 zpm zpp ypm avdd pfet_06v0 ad=1.98p pd=7.2u as=1.98p ps=7.2u w=6.6u l=0.6u
X830 a_276_276# en bna avss nfet_06v0 ad=1.98p pd=7.2u as=1.98p ps=7.2u w=6.6u l=0.6u
X831 a_6084_108# znm avss avss nfet_06v0 ad=1.98p pd=7.2u as=1.98p ps=7.2u w=6.6u l=0.6u
X832 znp znp a_3684_276# avss nfet_06v0 ad=1.98p pd=7.2u as=1.98p ps=7.2u w=6.6u l=0.6u
X833 a_1560_811# a_1560_811# a_1788_984# avdd pfet_06v0 ad=1.98p pd=7.2u as=1.98p ps=7.2u w=6.6u l=0.6u
X834 a_564_276# bna a_540_276# avss nfet_06v0 ad=1.98p pd=7.2u as=1.98p ps=7.2u w=6.6u l=0.6u
X835 a_852_276# bnb bnb avss nfet_06v0 ad=1.98p pd=7.2u as=1.98p ps=7.2u w=6.6u l=0.6u
X836 a_3996_276# znp a_3972_276# avss nfet_06v0 ad=1.98p pd=7.2u as=1.98p ps=7.2u w=6.6u l=0.6u
X837 a_372_816# en bpa avdd pfet_06v0 ad=1.98p pd=7.2u as=1.98p ps=7.2u w=6.6u l=0.6u
X838 avdd bpa a_3780_816# avdd pfet_06v0 ad=1.98p pd=7.2u as=1.98p ps=7.2u w=6.6u l=0.6u
X839 zpm bpb znm avdd pfet_06v0 ad=1.98p pd=7.2u as=1.98p ps=7.2u w=6.6u l=0.6u
X840 o zpm avdd avdd pfet_06v0 ad=1.98p pd=7.2u as=1.98p ps=7.2u w=6.6u l=0.6u
X841 a_2004_108# znp a_1980_108# avss nfet_06v0 ad=1.98p pd=7.2u as=1.98p ps=7.2u w=6.6u l=0.6u
X842 bpb bpb bpa_ avdd pfet_06v0 ad=1.98p pd=7.2u as=1.98p ps=7.2u w=6.6u l=0.6u
X843 a_180_276# en enb avss nfet_06v0 ad=1.98p pd=7.2u as=1.98p ps=7.2u w=6.6u l=0.6u
X844 bpb bpb bpa_ avdd pfet_06v0 ad=1.98p pd=7.2u as=1.98p ps=7.2u w=6.6u l=0.6u
X845 a_1560_811# a_1560_811# a_1692_984# avdd pfet_06v0 ad=1.98p pd=7.2u as=1.98p ps=7.2u w=6.6u l=0.6u
X846 a_468_276# bna a_444_276# avss nfet_06v0 ad=1.98p pd=7.2u as=1.98p ps=7.2u w=6.6u l=0.6u
X847 a_6276_108# enb avss avss nfet_06v0 ad=1.98p pd=7.2u as=1.98p ps=7.2u w=6.6u l=0.6u
X848 znp znp a_3876_276# avss nfet_06v0 ad=1.98p pd=7.2u as=1.98p ps=7.2u w=6.6u l=0.6u
X849 a_756_276# bnb bnb avss nfet_06v0 ad=1.98p pd=7.2u as=1.98p ps=7.2u w=6.6u l=0.6u
X850 a_276_816# enb bpa avdd pfet_06v0 ad=1.98p pd=7.2u as=1.98p ps=7.2u w=6.6u l=0.6u
X851 a_3660_816# bpb znp avdd pfet_06v0 ad=1.98p pd=7.2u as=1.98p ps=7.2u w=6.6u l=0.6u
X852 a_3996_816# bpb znp avdd pfet_06v0 ad=1.98p pd=7.2u as=1.98p ps=7.2u w=6.6u l=0.6u
X853 bpb bpb bpa_ avdd pfet_06v0 ad=1.98p pd=7.2u as=1.98p ps=7.2u w=6.6u l=0.6u
X854 bpb bpb bpa_ avdd pfet_06v0 ad=1.98p pd=7.2u as=1.98p ps=7.2u w=6.6u l=0.6u
X855 a_1908_108# bna a_1884_108# avss nfet_06v0 ad=1.98p pd=7.2u as=1.98p ps=7.2u w=6.6u l=0.6u
X856 a_1560_811# a_1560_811# a_1596_984# avdd pfet_06v0 ad=1.98p pd=7.2u as=1.98p ps=7.2u w=6.6u l=0.6u
X857 znm bpb zpm avdd pfet_06v0 ad=1.98p pd=7.2u as=1.98p ps=7.2u w=6.6u l=0.6u
X858 a_660_276# bnb bnb avss nfet_06v0 ad=1.98p pd=7.2u as=1.98p ps=7.2u w=6.6u l=0.6u
X859 a_3012_276# inp xn avss nfet_06v0 ad=1.98p pd=7.2u as=1.98p ps=7.2u w=6.6u l=0.6u
X860 a_6180_108# znm avss avss nfet_06v0 ad=1.98p pd=7.2u as=1.98p ps=7.2u w=6.6u l=0.6u
X861 a_180_816# en enb avdd pfet_06v0 ad=1.98p pd=7.2u as=1.98p ps=7.2u w=6.6u l=0.6u
X862 a_948_276# bnb bnb avss nfet_06v0 ad=1.98p pd=7.2u as=1.98p ps=7.2u w=6.6u l=0.6u
X863 a_468_816# bpa a_444_816# avdd pfet_06v0 ad=1.98p pd=7.2u as=1.98p ps=7.2u w=6.6u l=0.6u
X864 a_3900_816# bpa a_3876_816# avdd pfet_06v0 ad=1.98p pd=7.2u as=1.98p ps=7.2u w=6.6u l=0.6u
X865 zpm bnb a_5268_108# avss nfet_06v0 ad=1.98p pd=7.2u as=1.98p ps=7.2u w=6.6u l=0.6u
X866 bpb bpb bpa_ avdd pfet_06v0 ad=1.98p pd=7.2u as=1.98p ps=7.2u w=6.6u l=0.6u
X867 ypm zpp a_4884_984# avdd pfet_06v0 ad=1.98p pd=7.2u as=1.98p ps=7.2u w=6.6u l=0.6u
X868 bpb bpb bpa_ avdd pfet_06v0 ad=1.98p pd=7.2u as=1.98p ps=7.2u w=6.6u l=0.6u
X869 a_3012_816# zpp ypm avdd pfet_06v0 ad=1.98p pd=7.2u as=1.98p ps=7.2u w=6.6u l=0.6u
X870 zpm bnb a_5172_108# avss nfet_06v0 ad=1.98p pd=7.2u as=1.98p ps=7.2u w=6.6u l=0.6u
X871 zpm bnb a_5460_108# avss nfet_06v0 ad=1.98p pd=7.2u as=1.98p ps=7.2u w=6.6u l=0.6u
X872 a_948_816# bpa a_924_816# avdd pfet_06v0 ad=1.98p pd=7.2u as=1.98p ps=7.2u w=6.6u l=0.6u
X873 a_5772_108# znp a_5748_108# avss nfet_06v0 ad=1.98p pd=7.2u as=1.98p ps=7.2u w=6.6u l=0.6u
X874 bnb bnb a_1188_108# avss nfet_06v0 ad=1.98p pd=7.2u as=1.98p ps=7.2u w=6.6u l=0.6u
X875 o znm a_6180_276# avss nfet_06v0 ad=1.98p pd=7.2u as=1.98p ps=7.2u w=6.6u l=0.6u
X876 avdd en a_180_984# avdd pfet_06v0 ad=1.98p pd=7.2u as=1.98p ps=7.2u w=6.6u l=0.6u
X877 ynm znp a_5076_108# avss nfet_06v0 ad=1.98p pd=7.2u as=1.98p ps=7.2u w=6.6u l=0.6u
X878 bpa_ bpa a_468_984# avdd pfet_06v0 ad=1.98p pd=7.2u as=1.98p ps=7.2u w=6.6u l=0.6u
X879 zpm bnb a_5364_108# avss nfet_06v0 ad=1.98p pd=7.2u as=1.98p ps=7.2u w=6.6u l=0.6u
X880 ynm znp a_5652_108# avss nfet_06v0 ad=1.98p pd=7.2u as=1.98p ps=7.2u w=6.6u l=0.6u
X881 avss znm a_5940_108# avss nfet_06v0 ad=1.98p pd=7.2u as=1.98p ps=7.2u w=6.6u l=0.6u
X882 bnb bnb a_1092_108# avss nfet_06v0 ad=1.98p pd=7.2u as=1.98p ps=7.2u w=6.6u l=0.6u
X883 o znm a_6084_276# avss nfet_06v0 ad=1.98p pd=7.2u as=1.98p ps=7.2u w=6.6u l=0.6u
X884 a_4212_984# zpp a_4188_984# avdd pfet_06v0 ad=1.98p pd=7.2u as=1.98p ps=7.2u w=6.6u l=0.6u
X885 avdd en a_372_984# avdd pfet_06v0 ad=1.98p pd=7.2u as=1.98p ps=7.2u w=6.6u l=0.6u
X886 avdd zpm o avdd pfet_06v0 ad=1.98p pd=7.2u as=1.98p ps=7.2u w=6.6u l=0.6u
X887 bpa_ bpb bpb avdd pfet_06v0 ad=1.98p pd=7.2u as=1.98p ps=7.2u w=6.6u l=0.6u
X888 ynp znp a_2100_276# avss nfet_06v0 ad=1.98p pd=7.2u as=1.98p ps=7.2u w=6.6u l=0.6u
X889 ynm znp a_5556_108# avss nfet_06v0 ad=1.98p pd=7.2u as=1.98p ps=7.2u w=6.6u l=0.6u
X890 avdd bpa a_948_984# avdd pfet_06v0 ad=1.98p pd=7.2u as=1.98p ps=7.2u w=6.6u l=0.6u
X891 a_2412_276# znp a_2388_276# avss nfet_06v0 ad=1.98p pd=7.2u as=1.98p ps=7.2u w=6.6u l=0.6u
X892 avss znp a_5844_108# avss nfet_06v0 ad=1.98p pd=7.2u as=1.98p ps=7.2u w=6.6u l=0.6u
X893 a_4404_108# bnb zpp avss nfet_06v0 ad=1.98p pd=7.2u as=1.98p ps=7.2u w=6.6u l=0.6u
X894 bnb bnb a_996_108# avss nfet_06v0 ad=1.98p pd=7.2u as=1.98p ps=7.2u w=6.6u l=0.6u
X895 a_4692_108# bna a_4668_108# avss nfet_06v0 ad=1.98p pd=7.2u as=1.98p ps=7.2u w=6.6u l=0.6u
X896 a_4116_984# bpa a_4092_984# avdd pfet_06v0 ad=1.98p pd=7.2u as=1.98p ps=7.2u w=6.6u l=0.6u
X897 znm enb a_6276_276# avss nfet_06v0 ad=1.98p pd=7.2u as=1.98p ps=7.2u w=6.6u l=0.6u
X898 bpa_ enb a_276_984# avdd pfet_06v0 ad=1.98p pd=7.2u as=1.98p ps=7.2u w=6.6u l=0.6u
X899 avdd zpm o avdd pfet_06v0 ad=1.98p pd=7.2u as=1.98p ps=7.2u w=6.6u l=0.6u
X900 a_2028_276# znp a_2004_276# avss nfet_06v0 ad=1.98p pd=7.2u as=1.98p ps=7.2u w=6.6u l=0.6u
X901 bpa_ bpb bpb avdd pfet_06v0 ad=1.98p pd=7.2u as=1.98p ps=7.2u w=6.6u l=0.6u
X902 bpa_ bpb bpb avdd pfet_06v0 ad=1.98p pd=7.2u as=1.98p ps=7.2u w=6.6u l=0.6u
X903 avss znp a_2292_276# avss nfet_06v0 ad=1.98p pd=7.2u as=1.98p ps=7.2u w=6.6u l=0.6u
X904 xp0 inm ynp avdd pfet_06v0 ad=1.98p pd=7.2u as=1.98p ps=7.2u w=6.6u l=0.6u
X905 xp1 bpa a_2388_816# avdd pfet_06v0 ad=1.98p pd=7.2u as=1.98p ps=7.2u w=6.6u l=0.6u
X906 a_4308_108# bna a_4284_108# avss nfet_06v0 ad=1.98p pd=7.2u as=1.98p ps=7.2u w=6.6u l=0.6u
X907 a_4596_108# bnb zpp avss nfet_06v0 ad=1.98p pd=7.2u as=1.98p ps=7.2u w=6.6u l=0.6u
X908 a_4884_108# znp a_4860_108# avss nfet_06v0 ad=1.98p pd=7.2u as=1.98p ps=7.2u w=6.6u l=0.6u
X909 znp bpb a_3996_816# avdd pfet_06v0 ad=1.98p pd=7.2u as=1.98p ps=7.2u w=6.6u l=0.6u
X910 a_3132_984# zpp a_3108_984# avdd pfet_06v0 ad=1.98p pd=7.2u as=1.98p ps=7.2u w=6.6u l=0.6u
X911 zpm en a_6276_816# avdd pfet_06v0 ad=1.98p pd=7.2u as=1.98p ps=7.2u w=6.6u l=0.6u
X912 bpa_ bpb bpb avdd pfet_06v0 ad=1.98p pd=7.2u as=1.98p ps=7.2u w=6.6u l=0.6u
X913 a_2220_276# znp a_2196_276# avss nfet_06v0 ad=1.98p pd=7.2u as=1.98p ps=7.2u w=6.6u l=0.6u
X914 a_5604_276# znp ynm avss nfet_06v0 ad=1.98p pd=7.2u as=1.98p ps=7.2u w=6.6u l=0.6u
X915 xp0 bpa a_2004_816# avdd pfet_06v0 ad=1.98p pd=7.2u as=1.98p ps=7.2u w=6.6u l=0.6u
X916 a_1044_276# bnb bnb avss nfet_06v0 ad=1.98p pd=7.2u as=1.98p ps=7.2u w=6.6u l=0.6u
X917 a_5892_276# znm avss avss nfet_06v0 ad=1.98p pd=7.2u as=1.98p ps=7.2u w=6.6u l=0.6u
X918 avdd bpa a_2292_816# avdd pfet_06v0 ad=1.98p pd=7.2u as=1.98p ps=7.2u w=6.6u l=0.6u
X919 a_1332_276# bnb bnb avss nfet_06v0 ad=1.98p pd=7.2u as=1.98p ps=7.2u w=6.6u l=0.6u
X920 a_4500_108# bnb zpp avss nfet_06v0 ad=1.98p pd=7.2u as=1.98p ps=7.2u w=6.6u l=0.6u
X921 a_4788_108# bna a_4764_108# avss nfet_06v0 ad=1.98p pd=7.2u as=1.98p ps=7.2u w=6.6u l=0.6u
X922 a_3036_984# zpp a_3012_984# avdd pfet_06v0 ad=1.98p pd=7.2u as=1.98p ps=7.2u w=6.6u l=0.6u
X923 a_5508_276# bnb zpm avss nfet_06v0 ad=1.98p pd=7.2u as=1.98p ps=7.2u w=6.6u l=0.6u
X924 a_3324_984# zpp a_3300_984# avdd pfet_06v0 ad=1.98p pd=7.2u as=1.98p ps=7.2u w=6.6u l=0.6u
X925 a_3564_816# bpb znp avdd pfet_06v0 ad=1.98p pd=7.2u as=1.98p ps=7.2u w=6.6u l=0.6u
X926 a_5796_276# znp a_5772_276# avss nfet_06v0 ad=1.98p pd=7.2u as=1.98p ps=7.2u w=6.6u l=0.6u
X927 xp0 inp ynm avdd pfet_06v0 ad=1.98p pd=7.2u as=1.98p ps=7.2u w=6.6u l=0.6u
X928 zpm bpb znm avdd pfet_06v0 ad=1.98p pd=7.2u as=1.98p ps=7.2u w=6.6u l=0.6u
X929 o zpm avdd avdd pfet_06v0 ad=1.98p pd=7.2u as=1.98p ps=7.2u w=6.6u l=0.6u
X930 a_1236_276# bnb bnb avss nfet_06v0 ad=1.98p pd=7.2u as=1.98p ps=7.2u w=6.6u l=0.6u
X931 a_1524_276# bna a_1500_276# avss nfet_06v0 ad=1.98p pd=7.2u as=1.98p ps=7.2u w=6.6u l=0.6u
X932 a_1044_816# bpa a_1020_816# avdd pfet_06v0 ad=1.98p pd=7.2u as=1.98p ps=7.2u w=6.6u l=0.6u
X933 a_1812_276# bna a_1788_276# avss nfet_06v0 ad=1.98p pd=7.2u as=1.98p ps=7.2u w=6.6u l=0.6u
X934 a_4980_108# znp a_4956_108# avss nfet_06v0 ad=1.98p pd=7.2u as=1.98p ps=7.2u w=6.6u l=0.6u
X935 bpb bpb bpa_ avdd pfet_06v0 ad=1.98p pd=7.2u as=1.98p ps=7.2u w=6.6u l=0.6u
X936 znp znp a_3780_108# avss nfet_06v0 ad=1.98p pd=7.2u as=1.98p ps=7.2u w=6.6u l=0.6u
X937 a_372_108# enb bna avss nfet_06v0 ad=1.98p pd=7.2u as=1.98p ps=7.2u w=6.6u l=0.6u
X938 a_3228_984# zpp a_3204_984# avdd pfet_06v0 ad=1.98p pd=7.2u as=1.98p ps=7.2u w=6.6u l=0.6u
X939 a_3516_984# bpa a_3492_984# avdd pfet_06v0 ad=1.98p pd=7.2u as=1.98p ps=7.2u w=6.6u l=0.6u
X940 a_5988_276# znm avss avss nfet_06v0 ad=1.98p pd=7.2u as=1.98p ps=7.2u w=6.6u l=0.6u
X941 a_5700_276# znp ynm avss nfet_06v0 ad=1.98p pd=7.2u as=1.98p ps=7.2u w=6.6u l=0.6u
X942 ynp inm xp0 avdd pfet_06v0 ad=1.98p pd=7.2u as=1.98p ps=7.2u w=6.6u l=0.6u
X943 zpm zpp ypm avdd pfet_06v0 ad=1.98p pd=7.2u as=1.98p ps=7.2u w=6.6u l=0.6u
X944 a_1140_276# bnb bnb avss nfet_06v0 ad=1.98p pd=7.2u as=1.98p ps=7.2u w=6.6u l=0.6u
X945 a_5796_816# zpp ypm avdd pfet_06v0 ad=1.98p pd=7.2u as=1.98p ps=7.2u w=6.6u l=0.6u
X946 a_1428_276# bna a_1404_276# avss nfet_06v0 ad=1.98p pd=7.2u as=1.98p ps=7.2u w=6.6u l=0.6u
X947 a_1716_276# bna a_1692_276# avss nfet_06v0 ad=1.98p pd=7.2u as=1.98p ps=7.2u w=6.6u l=0.6u
X948 bpb bpb bpa_ avdd pfet_06v0 ad=1.98p pd=7.2u as=1.98p ps=7.2u w=6.6u l=0.6u
X949 a_1524_816# bpa a_1500_816# avdd pfet_06v0 ad=1.98p pd=7.2u as=1.98p ps=7.2u w=6.6u l=0.6u
X950 znp znp a_3684_108# avss nfet_06v0 ad=1.98p pd=7.2u as=1.98p ps=7.2u w=6.6u l=0.6u
X951 a_276_108# en bna avss nfet_06v0 ad=1.98p pd=7.2u as=1.98p ps=7.2u w=6.6u l=0.6u
X952 a_1560_811# a_1560_811# a_1788_816# avdd pfet_06v0 ad=1.98p pd=7.2u as=1.98p ps=7.2u w=6.6u l=0.6u
X953 a_3996_108# znp a_3972_108# avss nfet_06v0 ad=1.98p pd=7.2u as=1.98p ps=7.2u w=6.6u l=0.6u
X954 a_564_108# bna a_540_108# avss nfet_06v0 ad=1.98p pd=7.2u as=1.98p ps=7.2u w=6.6u l=0.6u
X955 a_3420_984# zpp a_3396_984# avdd pfet_06v0 ad=1.98p pd=7.2u as=1.98p ps=7.2u w=6.6u l=0.6u
X956 a_852_108# bnb bnb avss nfet_06v0 ad=1.98p pd=7.2u as=1.98p ps=7.2u w=6.6u l=0.6u
X957 a_2244_984# bpa xp0 avdd pfet_06v0 ad=1.98p pd=7.2u as=1.98p ps=7.2u w=6.6u l=0.6u
X958 ynp inm xp1 avdd pfet_06v0 ad=1.98p pd=7.2u as=1.98p ps=7.2u w=6.6u l=0.6u
X959 zpm bpb znm avdd pfet_06v0 ad=1.98p pd=7.2u as=1.98p ps=7.2u w=6.6u l=0.6u
X960 o zpm avdd avdd pfet_06v0 ad=1.98p pd=7.2u as=1.98p ps=7.2u w=6.6u l=0.6u
X961 a_1620_276# bna a_1596_276# avss nfet_06v0 ad=1.98p pd=7.2u as=1.98p ps=7.2u w=6.6u l=0.6u
X962 ynm znp a_4980_276# avss nfet_06v0 ad=1.98p pd=7.2u as=1.98p ps=7.2u w=6.6u l=0.6u
X963 bpb bpb bpa_ avdd pfet_06v0 ad=1.98p pd=7.2u as=1.98p ps=7.2u w=6.6u l=0.6u
X964 bpb bpb bpa_ avdd pfet_06v0 ad=1.98p pd=7.2u as=1.98p ps=7.2u w=6.6u l=0.6u
X965 znp znp a_3876_108# avss nfet_06v0 ad=1.98p pd=7.2u as=1.98p ps=7.2u w=6.6u l=0.6u
X966 a_180_108# en enb avss nfet_06v0 ad=1.98p pd=7.2u as=1.98p ps=7.2u w=6.6u l=0.6u
X967 a_1560_811# a_1560_811# a_1692_816# avdd pfet_06v0 ad=1.98p pd=7.2u as=1.98p ps=7.2u w=6.6u l=0.6u
X968 a_756_108# bnb bnb avss nfet_06v0 ad=1.98p pd=7.2u as=1.98p ps=7.2u w=6.6u l=0.6u
X969 a_468_108# bna a_444_108# avss nfet_06v0 ad=1.98p pd=7.2u as=1.98p ps=7.2u w=6.6u l=0.6u
X970 ynm inp xp0 avdd pfet_06v0 ad=1.98p pd=7.2u as=1.98p ps=7.2u w=6.6u l=0.6u
X971 ynm inp xp1 avdd pfet_06v0 ad=1.98p pd=7.2u as=1.98p ps=7.2u w=6.6u l=0.6u
X972 a_2724_984# zpp avdd avdd pfet_06v0 ad=1.98p pd=7.2u as=1.98p ps=7.2u w=6.6u l=0.6u
X973 a_4908_276# znp a_4884_276# avss nfet_06v0 ad=1.98p pd=7.2u as=1.98p ps=7.2u w=6.6u l=0.6u
X974 a_1560_811# a_1560_811# a_1596_816# avdd pfet_06v0 ad=1.98p pd=7.2u as=1.98p ps=7.2u w=6.6u l=0.6u
X975 znm bpb zpm avdd pfet_06v0 ad=1.98p pd=7.2u as=1.98p ps=7.2u w=6.6u l=0.6u
X976 a_3012_108# inp xn avss nfet_06v0 ad=1.98p pd=7.2u as=1.98p ps=7.2u w=6.6u l=0.6u
X977 a_660_108# bnb bnb avss nfet_06v0 ad=1.98p pd=7.2u as=1.98p ps=7.2u w=6.6u l=0.6u
X978 a_948_108# bnb bnb avss nfet_06v0 ad=1.98p pd=7.2u as=1.98p ps=7.2u w=6.6u l=0.6u
X979 a_2340_984# bpa avdd avdd pfet_06v0 ad=1.98p pd=7.2u as=1.98p ps=7.2u w=6.6u l=0.6u
X980 a_2628_984# bpa xp1 avdd pfet_06v0 ad=1.98p pd=7.2u as=1.98p ps=7.2u w=6.6u l=0.6u
X981 a_2916_984# zpp avdd avdd pfet_06v0 ad=1.98p pd=7.2u as=1.98p ps=7.2u w=6.6u l=0.6u
X982 bpa_ bpb bpb avdd pfet_06v0 ad=1.98p pd=7.2u as=1.98p ps=7.2u w=6.6u l=0.6u
X983 bpa_ bpb bpb avdd pfet_06v0 ad=1.98p pd=7.2u as=1.98p ps=7.2u w=6.6u l=0.6u
X984 avss en a_180_276# avss nfet_06v0 ad=1.98p pd=7.2u as=1.98p ps=7.2u w=6.6u l=0.6u
X985 ypm zpp a_4884_816# avdd pfet_06v0 ad=1.98p pd=7.2u as=1.98p ps=7.2u w=6.6u l=0.6u
X986 a_492_276# bna a_468_276# avss nfet_06v0 ad=1.98p pd=7.2u as=1.98p ps=7.2u w=6.6u l=0.6u
X987 avdd zpm o avdd pfet_06v0 ad=1.98p pd=7.2u as=1.98p ps=7.2u w=6.6u l=0.6u
X988 bpa_ bpa a_1044_984# avdd pfet_06v0 ad=1.98p pd=7.2u as=1.98p ps=7.2u w=6.6u l=0.6u
X989 a_2820_984# zpp ypp avdd pfet_06v0 ad=1.98p pd=7.2u as=1.98p ps=7.2u w=6.6u l=0.6u
X990 a_4212_276# bna a_4188_276# avss nfet_06v0 ad=1.98p pd=7.2u as=1.98p ps=7.2u w=6.6u l=0.6u
X991 bpa_ bpb bpb avdd pfet_06v0 ad=1.98p pd=7.2u as=1.98p ps=7.2u w=6.6u l=0.6u
X992 a_1644_984# a_1560_811# a_1560_811# avdd pfet_06v0 ad=1.98p pd=7.2u as=1.98p ps=7.2u w=6.6u l=0.6u
X993 avss enb a_372_276# avss nfet_06v0 ad=1.98p pd=7.2u as=1.98p ps=7.2u w=6.6u l=0.6u
X994 bna_ bnb a_660_276# avss nfet_06v0 ad=1.98p pd=7.2u as=1.98p ps=7.2u w=6.6u l=0.6u
X995 o znm a_6180_108# avss nfet_06v0 ad=1.98p pd=7.2u as=1.98p ps=7.2u w=6.6u l=0.6u
X996 avdd a_1560_811# a_1560_811# avdd pfet_06v0 ad=1.98p pd=7.2u as=1.98p ps=7.2u w=6.6u l=0.6u
X997 avdd en a_180_816# avdd pfet_06v0 ad=1.98p pd=7.2u as=1.98p ps=7.2u w=6.6u l=0.6u
X998 bna_ bnb a_948_276# avss nfet_06v0 ad=1.98p pd=7.2u as=1.98p ps=7.2u w=6.6u l=0.6u
X999 bpa_ bpa a_468_816# avdd pfet_06v0 ad=1.98p pd=7.2u as=1.98p ps=7.2u w=6.6u l=0.6u
X1000 a_4116_276# znp a_4092_276# avss nfet_06v0 ad=1.98p pd=7.2u as=1.98p ps=7.2u w=6.6u l=0.6u
X1001 bpa_ bpb bpb avdd pfet_06v0 ad=1.98p pd=7.2u as=1.98p ps=7.2u w=6.6u l=0.6u
X1002 avdd bpa a_1524_984# avdd pfet_06v0 ad=1.98p pd=7.2u as=1.98p ps=7.2u w=6.6u l=0.6u
X1003 bna_ en a_276_276# avss nfet_06v0 ad=1.98p pd=7.2u as=1.98p ps=7.2u w=6.6u l=0.6u
X1004 o znm a_6084_108# avss nfet_06v0 ad=1.98p pd=7.2u as=1.98p ps=7.2u w=6.6u l=0.6u
X1005 a_1836_984# a_1560_811# a_1560_811# avdd pfet_06v0 ad=1.98p pd=7.2u as=1.98p ps=7.2u w=6.6u l=0.6u
X1006 a_4212_816# zpp a_4188_816# avdd pfet_06v0 ad=1.98p pd=7.2u as=1.98p ps=7.2u w=6.6u l=0.6u
X1007 bna_ bna a_564_276# avss nfet_06v0 ad=1.98p pd=7.2u as=1.98p ps=7.2u w=6.6u l=0.6u
X1008 bna_ bnb a_852_276# avss nfet_06v0 ad=1.98p pd=7.2u as=1.98p ps=7.2u w=6.6u l=0.6u
X1009 avdd en a_372_816# avdd pfet_06v0 ad=1.98p pd=7.2u as=1.98p ps=7.2u w=6.6u l=0.6u
X1010 bpa_ bpb bpb avdd pfet_06v0 ad=1.98p pd=7.2u as=1.98p ps=7.2u w=6.6u l=0.6u
X1011 ynp znp a_2100_108# avss nfet_06v0 ad=1.98p pd=7.2u as=1.98p ps=7.2u w=6.6u l=0.6u
X1012 avdd bpa a_948_816# avdd pfet_06v0 ad=1.98p pd=7.2u as=1.98p ps=7.2u w=6.6u l=0.6u
X1013 a_2412_108# znp a_2388_108# avss nfet_06v0 ad=1.98p pd=7.2u as=1.98p ps=7.2u w=6.6u l=0.6u
X1014 a_4020_276# znp a_3996_276# avss nfet_06v0 ad=1.98p pd=7.2u as=1.98p ps=7.2u w=6.6u l=0.6u
X1015 znm enb a_6276_108# avss nfet_06v0 ad=1.98p pd=7.2u as=1.98p ps=7.2u w=6.6u l=0.6u
X1016 a_1740_984# a_1560_811# a_1560_811# avdd pfet_06v0 ad=1.98p pd=7.2u as=1.98p ps=7.2u w=6.6u l=0.6u
X1017 a_4116_816# bpa a_4092_816# avdd pfet_06v0 ad=1.98p pd=7.2u as=1.98p ps=7.2u w=6.6u l=0.6u
X1018 bna_ bnb a_756_276# avss nfet_06v0 ad=1.98p pd=7.2u as=1.98p ps=7.2u w=6.6u l=0.6u
X1019 ypm inp a_3108_276# avss nfet_06v0 ad=1.98p pd=7.2u as=1.98p ps=7.2u w=6.6u l=0.6u
X1020 bpa_ enb a_276_816# avdd pfet_06v0 ad=1.98p pd=7.2u as=1.98p ps=7.2u w=6.6u l=0.6u
X1021 bpa_ bpb bpb avdd pfet_06v0 ad=1.98p pd=7.2u as=1.98p ps=7.2u w=6.6u l=0.6u
X1022 avss znp a_2292_108# avss nfet_06v0 ad=1.98p pd=7.2u as=1.98p ps=7.2u w=6.6u l=0.6u
X1023 a_2028_108# znp a_2004_108# avss nfet_06v0 ad=1.98p pd=7.2u as=1.98p ps=7.2u w=6.6u l=0.6u
X1024 bpa_ bpb bpb avdd pfet_06v0 ad=1.98p pd=7.2u as=1.98p ps=7.2u w=6.6u l=0.6u
X1025 zpm bpb znm avdd pfet_06v0 ad=1.98p pd=7.2u as=1.98p ps=7.2u w=6.6u l=0.6u
X1026 a_5412_984# zpp a_5388_984# avdd pfet_06v0 ad=1.98p pd=7.2u as=1.98p ps=7.2u w=6.6u l=0.6u
X1027 znp bpb a_3996_816# avdd pfet_06v0 ad=1.98p pd=7.2u as=1.98p ps=7.2u w=6.6u l=0.6u
X1028 ypm inp a_3012_276# avss nfet_06v0 ad=1.98p pd=7.2u as=1.98p ps=7.2u w=6.6u l=0.6u
X1029 a_3324_276# bna a_3300_276# avss nfet_06v0 ad=1.98p pd=7.2u as=1.98p ps=7.2u w=6.6u l=0.6u
X1030 a_3612_276# znp a_3588_276# avss nfet_06v0 ad=1.98p pd=7.2u as=1.98p ps=7.2u w=6.6u l=0.6u
X1031 bpa_ bpb bpb avdd pfet_06v0 ad=1.98p pd=7.2u as=1.98p ps=7.2u w=6.6u l=0.6u
X1032 a_3132_816# zpp a_3108_816# avdd pfet_06v0 ad=1.98p pd=7.2u as=1.98p ps=7.2u w=6.6u l=0.6u
X1033 a_5604_108# znp ynm avss nfet_06v0 ad=1.98p pd=7.2u as=1.98p ps=7.2u w=6.6u l=0.6u
X1034 a_2220_108# znp a_2196_108# avss nfet_06v0 ad=1.98p pd=7.2u as=1.98p ps=7.2u w=6.6u l=0.6u
X1035 a_5892_108# znm avss avss nfet_06v0 ad=1.98p pd=7.2u as=1.98p ps=7.2u w=6.6u l=0.6u
X1036 zpm bpb znm avdd pfet_06v0 ad=1.98p pd=7.2u as=1.98p ps=7.2u w=6.6u l=0.6u
X1037 a_5316_984# zpp a_5292_984# avdd pfet_06v0 ad=1.98p pd=7.2u as=1.98p ps=7.2u w=6.6u l=0.6u
X1038 a_1044_108# bnb bnb avss nfet_06v0 ad=1.98p pd=7.2u as=1.98p ps=7.2u w=6.6u l=0.6u
X1039 a_1332_108# bnb bnb avss nfet_06v0 ad=1.98p pd=7.2u as=1.98p ps=7.2u w=6.6u l=0.6u
C0 zpm znm 15.9761f
C1 bna a_4332_108# 1.62398f
C2 xp0 inp 1.56737f
C3 avdd zpp 80.8802f
C4 ypm zpp 12.546f
C5 zpm bpb 7.74006f
C6 zpm bnb 5.24218f
C7 znm o 39.9977f
C8 znp znm 5.94734f
C9 znm enb 2.13581f
C10 ynm xp1 2.75095f
C11 ynm inp 6.43281f
C12 bnb bna_ 15.3766f
C13 ypm xn 1.10649f
C14 en zpp 6.20059f
C15 znm avdd 15.0028f
C16 zpm avss 8.59289f
C17 zpp a_4332_108# 2.53545f
C18 bpa_ enb 1.44426f
C19 znp bpb 5.59f
C20 znp bnb 9.80187f
C21 bnb enb 1.95993f
C22 znp a_3660_816# 1.6227f
C23 avss bna_ 17.5835f
C24 xp1 inp 1.56737f
C25 a_3564_816# bpb 1.13629f
C26 bpa_ avdd 24.3007f
C27 avdd bpb 74.4033f
C28 bnb avdd 1.29848f
C29 zpm inm 1.13442f
C30 o avss 18.4589f
C31 a_3660_816# avdd 1.43138f
C32 znp avss 76.7963f
C33 avss enb 42.6993f
C34 avdd avss 0.98193p
C35 bpa_ en 1.33939f
C36 a_3996_816# bpb 1.13629f
C37 en bpb 1.96008f
C38 o inm 6.9664f
C39 ypm avss 1.91831f
C40 ynm znm 2.72714f
C41 ynp o 1.37596f
C42 ynp znp 10.0172f
C43 a_3900_816# bpb 1.13629f
C44 bnb a_4332_108# 4.432f
C45 bna xn 1.76544f
C46 inp xn 3.66829f
C47 avss en 9.24374f
C48 avdd inm 14.8498f
C49 ypp avdd 25.3815f
C50 ynp avdd 5.22276f
C51 ypp ypm 1.15122f
C52 avss a_4332_108# 4.93627f
C53 inp znm 1.70255f
C54 enb bpa 1.4995f
C55 bna bpb 1.42587f
C56 bnb bna 10.4204f
C57 ynm avss 30.6754f
C58 xp0 inm 1.56839f
C59 xp0 ynp 2.75095f
C60 bpb a_1560_811# 1.19718f
C61 avdd bpa 61.4305f
C62 bna avss 70.973f
C63 inp avss 13.0274f
C64 ynp ynm 1.52753f
C65 en bpa 2.21044f
C66 xp0 bpa 1.48234f
C67 bpb zpp 7.77125f
C68 bnb zpp 4.8916f
C69 zpm o 42.5273f
C70 xp1 inm 1.56839f
C71 ynp xp1 2.75095f
C72 avss zpp 4.63854f
C73 zpm avdd 28.9049f
C74 znm bpb 8.04743f
C75 znm bnb 7.94137f
C76 ypm zpm 9.05863f
C77 znp enb 7.40656f
C78 avss xn 5.53409f
C79 a_3564_816# znp 1.6227f
C80 xp1 bpa 1.48234f
C81 ypp zpp 22.214f
C82 o avdd 31.8666f
C83 znm avss 33.0436f
C84 zpm en 2.06895f
C85 bpa_ bpb 42.3645f
C86 znp avdd 5.38398f
C87 avdd enb 5.15331f
C88 a_3660_816# bpb 1.13629f
C89 a_3564_816# avdd 1.43674f
C90 en bna_ 1.4299f
C91 inm xn 3.66741f
C92 ypp xn 1.10649f
C93 avss bpb 2.44549f
C94 bnb avss 69.2875f
C95 o en 1.16256f
C96 a_3996_816# znp 1.6227f
C97 ypm avdd 31.2222f
C98 en enb 5.85198f
C99 a_3900_816# znp 1.6227f
C100 bpa zpp 1.67045f
C101 a_3996_816# avdd 1.43712f
C102 avdd en 52.0781f
C103 xp0 avdd 4.46656f
C104 a_3900_816# avdd 1.43138f
C105 ynm o 1.23196f
C106 ynm znp 8.52938f
C107 bna bna_ 2.95474f
C108 avss inm 10.4124f
C109 ypp avss 1.86535f
C110 znp bna 2.50436f
C111 ynm avdd 5.37569f
C112 ynp avss 19.816f
C113 bna enb 2.29499f
C114 inp o 5.84491f
C115 bpa_ bpa 4.50883f
C116 bpa bpb 9.52617f
C117 zpm zpp 4.85362f
C118 bna avdd 1.14142f
C119 ypp inm 4.48782f
C120 ynp inm 5.36401f
C121 xp1 avdd 4.46656f
C122 inp avdd 12.6091f
C123 xp0 ynm 2.75095f
C124 avdd a_1560_811# 14.2517f
C125 ypm inp 3.30344f
C126 bna en 1.5757f
C127 o vsub 29.82998f
C128 avss vsub 83.95689f
C129 avdd vsub 0.93155p
C130 a_5988_108# vsub 6.8825f
C131 a_5508_108# vsub 1.11696f
C132 a_1524_108# vsub 1.00686f
C133 a_1500_108# vsub 1.00686f
C134 a_180_108# vsub 1.15758f
C135 a_3516_276# vsub 2.89337f
C136 a_3492_276# vsub 2.89337f
C137 a_3204_276# vsub 6.4416f
C138 bna_ vsub 1.40194f
C139 a_3036_816# vsub 2.52753f
C140 a_3012_816# vsub 2.52753f
C141 a_3564_816# vsub 1.66712f
C142 ypm vsub 2.121f
C143 ypp vsub 8.06285f
C144 ynm vsub 10.139f
C145 ynp vsub 4.87139f
C146 xp0 vsub 5.74578f
.ends

.subckt lpopamp inm inp out avdd avss vsub en ib
Xlpopamp_slice_0 inm inp out avdd avss en vsub zpm znm ib w_1258_130# lpopamp_slice
Xlpopamp_slice_1 inm inp out avdd avss en vsub zpm znm ib w_1258_1966# lpopamp_slice
X0 zpm out cap_mim_2f0_m4m5_noshield c_width=48u c_length=5.4u
X1 zpm out cap_mim_2f0_m4m5_noshield c_width=48u c_length=5.4u
X2 znm out cap_mim_2f0_m4m5_noshield c_width=48u c_length=5.4u
X3 znm out cap_mim_2f0_m4m5_noshield c_width=48u c_length=5.4u
X4 zpm out cap_mim_2f0_m4m5_noshield c_width=48u c_length=5.4u
X5 znm out cap_mim_2f0_m4m5_noshield c_width=48u c_length=5.4u
X6 zpm out cap_mim_2f0_m4m5_noshield c_width=48u c_length=5.4u
X7 zpm out cap_mim_2f0_m4m5_noshield c_width=48u c_length=5.4u
X8 znm out cap_mim_2f0_m4m5_noshield c_width=48u c_length=5.4u
X9 znm out cap_mim_2f0_m4m5_noshield c_width=48u c_length=5.4u
X10 znm out cap_mim_2f0_m4m5_noshield c_width=48u c_length=5.4u
X11 zpm out cap_mim_2f0_m4m5_noshield c_width=48u c_length=5.4u
X12 zpm out cap_mim_2f0_m4m5_noshield c_width=48u c_length=5.4u
X13 znm out cap_mim_2f0_m4m5_noshield c_width=48u c_length=5.4u
X14 zpm out cap_mim_2f0_m4m5_noshield c_width=48u c_length=5.4u
C0 inp avss 10.12823f
C1 avss ib 10.61382f
C2 znm out 73.27185f
C3 avdd avss 31.34475f
C4 inm avss 10.20764f
C5 avss out 8.9114f
C6 avss w_1258_130# 1.21461f
C7 zpm out 79.25575f
C8 en avss 9.09602f
C9 inp out 1.3791f
C10 out ib 1.26493f
C11 avdd w_1258_1966# 1.29765f
C12 avdd out 5.45591f
C13 inm out 1.51928f
C14 avdd vsub 10.69832f
C15 avss vsub -26.84332f
C16 ib vsub 3.62304f
C17 out vsub 71.00738f
C18 inp vsub 1.7609f
C19 en vsub 1.09619f
.ends
