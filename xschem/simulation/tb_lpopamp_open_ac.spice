** sch_path: /home/rodovalho/git/gf180mcu_rodovalho_ip__lpopamp/xschem/tb_lpopamp_open_ac.sch
**.subckt tb_lpopamp_open_ac
Xdut im_ ip out avdd avss avss en enb ibias lpopamp_ref
v_avss GND avss xavss
v_avdd avdd avss dc {xavdd} ac {xavdd_ac}
v_en en avss {xen*xavdd}
v_enb enb avss {(1-xen)*xavdd}
i_ibias avdd ibias {xen*xibias}
c_l out cm {xcl} m=1
c_i im_ im {xci} m=1
l_f out im_ {xlf} m=1
v_cm cm avss {xcm}
v_im im avss dc {xavdd/2}
v_ip ip avss dc {xavdd/2}
**** begin user architecture code

.include $PDK_ROOT/$PDK/libs.tech/ngspice/design.ngspice
.lib $PDK_ROOT/$PDK/libs.tech/ngspice/sm141064.ngspice typical
.lib $PDK_ROOT/$PDK/libs.tech/ngspice/sm141064.ngspice mimcap_typical

* no monte carlo
.param   sw_stat_global = 0   sw_stat_mismatch = 0

.temp 25

.option gmin=1e-15
.option cshunt=1e-15
.control
  * differential input
  alter v_ip   ac=0
  alter v_im   ac=1
  alter v_avdd ac=0

  op
  ac dec 100 0.1 10G

  * common-mode input
  alter v_ip   ac=1
  alter v_im   ac=1
  alter v_avdd ac=0

  ac dec 100 0.1 10G

  * power supply
  alter v_ip   ac=0
  alter v_im   ac=0
  alter v_avdd ac=1

  ac dec 100 0.1 10G

  let idd = op.i(v_avdd)
  let av = db(ac1.out)
  let ph = cphase(ac1.out)*180/(4*atan(1))
  let cmrr = db(ac1.out/ac2.out)
  let psrr = db(ac1.out/ac3.out)

  meas ac av0p1hz find av at=0.1
  meas ac gbw when av=0
  meas ac pm180 when ph=-180
  meas ac pm find ph at=gbw
  meas ac gm find av at=pm180

  meas ac cmrr0p1hz find cmrr at=0.1
  meas ac psrr0p1hz find psrr at=0.1

  plot av cmrr psrr
  plot ph
  print idd
.endc

.param xavdd  = 5
.param xavss  = 0
.param xcm    = 2.5
.param xvin   = 0
.param xvout  = 0

.param xen =  1
.param xip =  0
.param xim =  1

.param xavdd_ac = 0
.param xvin_ac  = 1
.param xvout_ac = 0

.param xibias = 4u

.param xci    = 1T
.param xri    = 1T
.param xlf    = 1T
.param xrf    = 1f
.param xcl    = 30p
.param xrl    = 5k

**** end user architecture code
**.ends

* expanding   symbol:  lpopamp_ref.sym # of pins=9
** sym_path: /home/rodovalho/git/gf180mcu_rodovalho_ip__lpopamp/xschem/lpopamp_ref.sym
** sch_path: /home/rodovalho/git/gf180mcu_rodovalho_ip__lpopamp/xschem/lpopamp_ref.sch
.subckt lpopamp_ref im ip o avdd avss vsub en enb ibias
*.iopin avdd
*.iopin avss
*.iopin ip
*.iopin im
*.iopin o
*.iopin ibias
*.iopin en
*.iopin enb
*.iopin vsub
xslice[3] im ip o avdd avss en enb bpa bpb bnb zpp zpm zn znp znm lpopamp_slice
xslice[2] im ip o avdd avss en enb bpa bpb bnb zpp zpm zn znp znm lpopamp_slice
xslice[1] im ip o avdd avss en enb bpa bpb bnb zpp zpm zn znp znm lpopamp_slice
xslice[0] im ip o avdd avss en enb bpa bpb bnb zpp zpm zn znp znm lpopamp_slice
ralias_ibias ibias bnb 1 m=1
C1 o zpm 3p m=1
C2 o znm 3p m=1
C3 avdd zpp 3p m=1
C4 avss znp 3p m=1
.ends

* expanding   symbol:  lpopamp_slice.sym # of pins=16
** sym_path: /home/rodovalho/git/gf180mcu_rodovalho_ip__lpopamp/xschem/lpopamp_slice.sym
** sch_path: /home/rodovalho/git/gf180mcu_rodovalho_ip__lpopamp/xschem/lpopamp_slice.sch
.subckt lpopamp_slice im ip o avdd avss en enb bpa bpb bnb zpp zpm zn znp znm
*.iopin avdd
*.iopin avss
*.iopin ip
*.iopin im
*.iopin o
*.iopin bpa
*.iopin bpb
*.iopin bnb
*.iopin zpm
*.iopin zpp
*.iopin znm
*.iopin znp
*.iopin zn
*.iopin vsub
*.iopin en
*.iopin enb
x00b[1] bnb bnb bna_[1] avss n8_1
x00b[0] bnb bnb bna_[0] avss n8_1
x02c[1] bpb bna avss avss n1_4
x02c[0] bpb bna avss avss n1_4
x02b[1] bpb bpb bpa_[1] avdd p8_1
x02b[0] bpb bpb bpa_[0] avdd p8_1
x02a[1] bpa_[1] bpa avdd avdd p1_4
x02a[0] bpa_[0] bpa avdd avdd p1_4
x10b[15] ynp im xp avdd p0
x10b[14] ynp im xp avdd p0
x10b[13] ynp im xp avdd p0
x10b[12] ynp im xp avdd p0
x10b[11] ynp im xp avdd p0
x10b[10] ynp im xp avdd p0
x10b[9] ynp im xp avdd p0
x10b[8] ynp im xp avdd p0
x10b[7] ynp im xp avdd p0
x10b[6] ynp im xp avdd p0
x10b[5] ynp im xp avdd p0
x10b[4] ynp im xp avdd p0
x10b[3] ynp im xp avdd p0
x10b[2] ynp im xp avdd p0
x10b[1] ynp im xp avdd p0
x10b[0] ynp im xp avdd p0
x11a[1] xp bpa avdd avdd p1_4
x11a[0] xp bpa avdd avdd p1_4
x11b[15] ynm ip xp avdd p0
x11b[14] ynm ip xp avdd p0
x11b[13] ynm ip xp avdd p0
x11b[12] ynm ip xp avdd p0
x11b[11] ynm ip xp avdd p0
x11b[10] ynm ip xp avdd p0
x11b[9] ynm ip xp avdd p0
x11b[8] ynm ip xp avdd p0
x11b[7] ynm ip xp avdd p0
x11b[6] ynm ip xp avdd p0
x11b[5] ynm ip xp avdd p0
x11b[4] ynm ip xp avdd p0
x11b[3] ynm ip xp avdd p0
x11b[2] ynm ip xp avdd p0
x11b[1] ynm ip xp avdd p0
x11b[0] ynm ip xp avdd p0
x13c[1] znp zn ynp avss n3_1
x13c[0] znp zn ynp avss n3_1
x3d[3] ynp zn avss avss n1_4
x3d[2] ynp zn avss avss n1_4
x3d[1] ynp zn avss avss n1_4
x3d[0] ynp zn avss avss n1_4
x14f[3] ynm zn avss avss n1_4
x14f[2] ynm zn avss avss n1_4
x14f[1] ynm zn avss avss n1_4
x14f[0] ynm zn avss avss n1_4
x14e[1] znm zn ynm avss n3_1
x14e[0] znm zn ynm avss n3_1
x10a[1] xp bpa avdd avdd p1_4
x10a[0] xp bpa avdd avdd p1_4
x14c[1] znm bpb zpm avdd p4_1
x14c[0] znm bpb zpm avdd p4_1
x14d[1] zpm bnb znm avss n4_1
x14d[0] zpm bnb znm avss n4_1
x21b[1] o znm avss avss n4_1
x21b[0] o znm avss avss n4_1
x21a[1] o zpm avdd avdd p4_1
x21a[0] o zpm avdd avdd p4_1
x01c[1] bna enb avss avss n0
x01c[0] bna enb avss avss n0
x01b[1] bna_[1] en bna avss n0
x01b[0] bna_[0] en bna avss n0
x00c[1] bna_[1] bna avss avss n1_4
x00c[0] bna_[0] bna avss avss n1_4
x03a[1] bpa en avdd avdd p0
x03a[0] bpa en avdd avdd p0
x03b[1] bpa_[1] enb bpa avdd p0
x03b[0] bpa_[0] enb bpa avdd p0
x00a[1] avdd bpa avdd avdd p1_4
x00a[0] avdd bpa avdd avdd p1_4
x20b[1] znm enb avss avss n0
x20b[0] znm enb avss avss n0
x20a[1] zpm en avdd avdd p0
x20a[0] zpm en avdd avdd p0
x1[1] zpm bpa avdd avdd p1_4
x1[0] zpm bpa avdd avdd p1_4
x3[3] zn zn yn avss n3_1
x3[2] zn zn yn avss n3_1
x3[1] zn zn yn avss n3_1
x3[0] zn zn yn avss n3_1
x4[7] yn zn avss avss n1_4
x4[6] yn zn avss avss n1_4
x4[5] yn zn avss avss n1_4
x4[4] yn zn avss avss n1_4
x4[3] yn zn avss avss n1_4
x4[2] yn zn avss avss n1_4
x4[1] yn zn avss avss n1_4
x4[0] yn zn avss avss n1_4
x5[3] wp1[1] bpa avdd avdd p1_4
x5[2] wp1[0] bpa avdd avdd p1_4
x5[1] wp1[1] bpa avdd avdd p1_4
x5[0] wp1[0] bpa avdd avdd p1_4
x6[3] zn bpb wp1[1] avdd p3_1
x6[2] zn bpb wp1[0] avdd p3_1
x6[1] zn bpb wp1[1] avdd p3_1
x6[0] zn bpb wp1[0] avdd p3_1
x7[1] znp bpb zpp avdd p4_1
x7[0] znp bpb zpp avdd p4_1
x8[1] zpp bnb znp avss n4_1
x8[0] zpp bnb znp avss n4_1
x9[1] zpp bpa avdd avdd p1_4
x9[0] zpp bpa avdd avdd p1_4
x11[1] kn znp avss avss n1_4
x11[0] kn znp avss avss n1_4
x13[1] kn bpb kp avdd p4_1
x13[0] kn bpb kp avdd p4_1
x14[1] kp bnb kn avss n4_1
x14[0] kp bnb kn avss n4_1
x15[1] kp zpp avdd avdd p1_4
x15[0] kp zpp avdd avdd p1_4
x17[1] kn kn avss avss n1_4
x17[0] kn kn avss avss n1_4
x19[1] kn bpb kp avdd p4_1
x19[0] kn bpb kp avdd p4_1
x20[1] kp bnb kn avss n4_1
x20[0] kp bnb kn avss n4_1
x21[1] kp kp avdd avdd p1_4
x21[0] kp kp avdd avdd p1_4
x23[1] o kn avss avss n4_1
x23[0] o kn avss avss n4_1
x27[1] o kp avdd avdd p4_1
x27[0] o kp avdd avdd p4_1
x2[1] kn enb avss avss n0
x2[0] kn enb avss avss n0
x10[1] kp en avdd avdd p0
x10[0] kp en avdd avdd p0
x12[15] yn im xp0 avdd p0
x12[14] yn im xp0 avdd p0
x12[13] yn im xp0 avdd p0
x12[12] yn im xp0 avdd p0
x12[11] yn im xp0 avdd p0
x12[10] yn im xp0 avdd p0
x12[9] yn im xp0 avdd p0
x12[8] yn im xp0 avdd p0
x12[7] yn im xp0 avdd p0
x12[6] yn im xp0 avdd p0
x12[5] yn im xp0 avdd p0
x12[4] yn im xp0 avdd p0
x12[3] yn im xp0 avdd p0
x12[2] yn im xp0 avdd p0
x12[1] yn im xp0 avdd p0
x12[0] yn im xp0 avdd p0
x16[1] xp0 bpa avdd avdd p1_4
x16[0] xp0 bpa avdd avdd p1_4
x18[15] yn ip xp0 avdd p0
x18[14] yn ip xp0 avdd p0
x18[13] yn ip xp0 avdd p0
x18[12] yn ip xp0 avdd p0
x18[11] yn ip xp0 avdd p0
x18[10] yn ip xp0 avdd p0
x18[9] yn ip xp0 avdd p0
x18[8] yn ip xp0 avdd p0
x18[7] yn ip xp0 avdd p0
x18[6] yn ip xp0 avdd p0
x18[5] yn ip xp0 avdd p0
x18[4] yn ip xp0 avdd p0
x18[3] yn ip xp0 avdd p0
x18[2] yn ip xp0 avdd p0
x18[1] yn ip xp0 avdd p0
x18[0] yn ip xp0 avdd p0
x22[1] xp0 bpa avdd avdd p1_4
x22[0] xp0 bpa avdd avdd p1_4
.ends

* expanding   symbol:  n8_1.sym # of pins=4
** sym_path: /home/rodovalho/git/gf180mcu_rodovalho_ip__lpopamp/xschem/n8_1.sym
** sch_path: /home/rodovalho/git/gf180mcu_rodovalho_ip__lpopamp/xschem/n8_1.sch
.subckt n8_1 D G S B
*.iopin D
*.iopin G
*.iopin S
*.iopin B
xr D G S B n4_1
xl D G S B n4_1
.ends

* expanding   symbol:  n1_4.sym # of pins=4
** sym_path: /home/rodovalho/git/gf180mcu_rodovalho_ip__lpopamp/xschem/n1_4.sym
** sch_path: /home/rodovalho/git/gf180mcu_rodovalho_ip__lpopamp/xschem/n1_4.sch
.subckt n1_4 D G S B
*.iopin D
*.iopin G
*.iopin S
*.iopin B
xd D G X B n1_2
xs X G S B n1_2
.ends

* expanding   symbol:  p8_1.sym # of pins=4
** sym_path: /home/rodovalho/git/gf180mcu_rodovalho_ip__lpopamp/xschem/p8_1.sym
** sch_path: /home/rodovalho/git/gf180mcu_rodovalho_ip__lpopamp/xschem/p8_1.sch
.subckt p8_1 D G S B
*.iopin D
*.iopin G
*.iopin S
*.iopin B
xl D G S B p4_1
xr D G S B p4_1
.ends

* expanding   symbol:  p1_4.sym # of pins=4
** sym_path: /home/rodovalho/git/gf180mcu_rodovalho_ip__lpopamp/xschem/p1_4.sym
** sch_path: /home/rodovalho/git/gf180mcu_rodovalho_ip__lpopamp/xschem/p1_4.sch
.subckt p1_4 D G S B
*.iopin D
*.iopin G
*.iopin S
*.iopin B
xs X G S B p1_2
xd D G X B p1_2
.ends

* expanding   symbol:  p0.sym # of pins=4
** sym_path: /home/rodovalho/git/gf180mcu_rodovalho_ip__lpopamp/xschem/p0.sym
** sch_path: /home/rodovalho/git/gf180mcu_rodovalho_ip__lpopamp/xschem/p0.sch
.subckt p0 D G S B
*.iopin D
*.iopin G
*.iopin S
*.iopin B
**** begin user architecture code

xo d g s b pfet_06v0 ad=0.54p pd=2.4u as=0.54p ps=2.4u w=5.4u l=0.6u

**** end user architecture code
.ends

* expanding   symbol:  n3_1.sym # of pins=4
** sym_path: /home/rodovalho/git/gf180mcu_rodovalho_ip__lpopamp/xschem/n3_1.sym
** sch_path: /home/rodovalho/git/gf180mcu_rodovalho_ip__lpopamp/xschem/n3_1.sch
.subckt n3_1 D G S B
*.iopin D
*.iopin G
*.iopin S
*.iopin B
xr D G S B n1_1
xl D G S B n2_1
.ends

* expanding   symbol:  p4_1.sym # of pins=4
** sym_path: /home/rodovalho/git/gf180mcu_rodovalho_ip__lpopamp/xschem/p4_1.sym
** sch_path: /home/rodovalho/git/gf180mcu_rodovalho_ip__lpopamp/xschem/p4_1.sch
.subckt p4_1 D G S B
*.iopin D
*.iopin G
*.iopin S
*.iopin B
xl D G S B p2_1
xr D G S B p2_1
.ends

* expanding   symbol:  n4_1.sym # of pins=4
** sym_path: /home/rodovalho/git/gf180mcu_rodovalho_ip__lpopamp/xschem/n4_1.sym
** sch_path: /home/rodovalho/git/gf180mcu_rodovalho_ip__lpopamp/xschem/n4_1.sch
.subckt n4_1 D G S B
*.iopin D
*.iopin G
*.iopin S
*.iopin B
xr D G S B n2_1
xl D G S B n2_1
.ends

* expanding   symbol:  n0.sym # of pins=4
** sym_path: /home/rodovalho/git/gf180mcu_rodovalho_ip__lpopamp/xschem/n0.sym
** sch_path: /home/rodovalho/git/gf180mcu_rodovalho_ip__lpopamp/xschem/n0.sch
.subckt n0 D G S B
*.iopin D
*.iopin G
*.iopin S
*.iopin B
**** begin user architecture code

xl d g s b nfet_06v0 ad=0.54p pd=2.4u as=0.54p ps=2.4u w=5.4u l=0.6u

**** end user architecture code
.ends

* expanding   symbol:  p3_1.sym # of pins=4
** sym_path: /home/rodovalho/git/gf180mcu_rodovalho_ip__lpopamp/xschem/p3_1.sym
** sch_path: /home/rodovalho/git/gf180mcu_rodovalho_ip__lpopamp/xschem/p3_1.sch
.subckt p3_1 D G S B
*.iopin D
*.iopin G
*.iopin S
*.iopin B
xl D G S B p2_1
xr D G S B p1_1
.ends

* expanding   symbol:  n1_2.sym # of pins=4
** sym_path: /home/rodovalho/git/gf180mcu_rodovalho_ip__lpopamp/xschem/n1_2.sym
** sch_path: /home/rodovalho/git/gf180mcu_rodovalho_ip__lpopamp/xschem/n1_2.sch
.subckt n1_2 D G S B
*.iopin D
*.iopin G
*.iopin S
*.iopin B
xd D G X B n1_1
xs X G S B n1_1
.ends

* expanding   symbol:  p1_2.sym # of pins=4
** sym_path: /home/rodovalho/git/gf180mcu_rodovalho_ip__lpopamp/xschem/p1_2.sym
** sch_path: /home/rodovalho/git/gf180mcu_rodovalho_ip__lpopamp/xschem/p1_2.sch
.subckt p1_2 D G S B
*.iopin D
*.iopin G
*.iopin S
*.iopin B
xs X G S B p1_1
xd D G X B p1_1
.ends

* expanding   symbol:  n1_1.sym # of pins=4
** sym_path: /home/rodovalho/git/gf180mcu_rodovalho_ip__lpopamp/xschem/n1_1.sym
** sch_path: /home/rodovalho/git/gf180mcu_rodovalho_ip__lpopamp/xschem/n1_1.sch
.subckt n1_1 D G S B
*.iopin D
*.iopin G
*.iopin S
*.iopin B
**** begin user architecture code

xd d g x b nfet_06v0 ad=0.54p pd=2.4u as=0.54p ps=2.4u w=5.4u l=1.8u
xs x g s b nfet_06v0 ad=0.54p pd=2.4u as=0.54p ps=2.4u w=5.4u l=1.8u

**** end user architecture code
.ends

* expanding   symbol:  n2_1.sym # of pins=4
** sym_path: /home/rodovalho/git/gf180mcu_rodovalho_ip__lpopamp/xschem/n2_1.sym
** sch_path: /home/rodovalho/git/gf180mcu_rodovalho_ip__lpopamp/xschem/n2_1.sch
.subckt n2_1 D G S B
*.iopin D
*.iopin G
*.iopin S
*.iopin B
xr D G S B n1_1
xl D G S B n1_1
.ends

* expanding   symbol:  p2_1.sym # of pins=4
** sym_path: /home/rodovalho/git/gf180mcu_rodovalho_ip__lpopamp/xschem/p2_1.sym
** sch_path: /home/rodovalho/git/gf180mcu_rodovalho_ip__lpopamp/xschem/p2_1.sch
.subckt p2_1 D G S B
*.iopin D
*.iopin G
*.iopin S
*.iopin B
xl D G S B p1_1
xr D G S B p1_1
.ends

* expanding   symbol:  p1_1.sym # of pins=4
** sym_path: /home/rodovalho/git/gf180mcu_rodovalho_ip__lpopamp/xschem/p1_1.sym
** sch_path: /home/rodovalho/git/gf180mcu_rodovalho_ip__lpopamp/xschem/p1_1.sch
.subckt p1_1 D G S B
*.iopin D
*.iopin G
*.iopin S
*.iopin B
**** begin user architecture code

xl d g s b pfet_06v0 ad=0.54p pd=2.4u as=0.54p ps=2.4u w=5.4u l=1.8u
xr d g s b pfet_06v0 ad=0.54p pd=2.4u as=0.54p ps=2.4u w=5.4u l=1.8u

**** end user architecture code
.ends

.GLOBAL GND
.end
